`include "constants.vams"
`include "disciplines.vams"

module task_metric_normalizer (
    input  electrical vin,
    input  electrical clk,
    input  electrical mode,
    input  electrical rst,
    output electrical out,
    output electrical metric
);
parameter real vth = 0.45;
parameter real vhi = 0.9;
parameter real tr = 200p;
real out_v;
real metric_v;
task normalize_metric;
    input real sample;
    input real norm_span;
    real raw_metric;
    begin
        if (sample < 0.0) out_v = 0.0;
        else if (sample > vhi) out_v = vhi;
        else out_v = sample;

        raw_metric = sample - vth;
        if (raw_metric < 0.0) raw_metric = -raw_metric;
        metric_v = vhi * raw_metric / norm_span;
        if (metric_v < 0.0) metric_v = 0.0;
        else if (metric_v > vhi) metric_v = vhi;
    end
endtask
analog begin
    @(initial_step) begin
        out_v = 0.0;
        metric_v = 0.0;
    end
    @(cross(V(clk) - vth, +1)) begin
        if (V(rst) > vth) begin
            out_v = 0.0;
            metric_v = 0.0;
        end else begin
            normalize_metric(V(vin), V(mode) > vth ? vhi : vth);
        end
    end
    V(out) <+ transition(out_v, 0.0, tr, tr);
    V(metric) <+ transition(metric_v, 0.0, tr, tr);
end
endmodule
