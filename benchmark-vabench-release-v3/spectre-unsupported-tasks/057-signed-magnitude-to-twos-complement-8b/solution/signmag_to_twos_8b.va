`include "constants.vams"
`include "disciplines.vams"

module signmag_to_twos_8b(
    input electrical sign,
    input electrical [6:0] mag,
    output electrical [7:0] y
);
    parameter real vdd = 0.9;
    parameter real vth = 0.45;
    parameter real tr = 20p;

    integer magnitude;
    integer value;

    analog begin
        magnitude = 0;
        if (V(mag[0]) > vth) magnitude = magnitude + 1;
        if (V(mag[1]) > vth) magnitude = magnitude + 2;
        if (V(mag[2]) > vth) magnitude = magnitude + 4;
        if (V(mag[3]) > vth) magnitude = magnitude + 8;
        if (V(mag[4]) > vth) magnitude = magnitude + 16;
        if (V(mag[5]) > vth) magnitude = magnitude + 32;
        if (V(mag[6]) > vth) magnitude = magnitude + 64;
        if ((V(sign) > vth) && (magnitude != 0)) value = 256 - magnitude;
        else value = magnitude;
        V(y[0]) <+ transition((((value & 1) != 0)) ? vdd : 0.0, 0, tr, tr);
        V(y[1]) <+ transition((((value & 2) != 0)) ? vdd : 0.0, 0, tr, tr);
        V(y[2]) <+ transition((((value & 4) != 0)) ? vdd : 0.0, 0, tr, tr);
        V(y[3]) <+ transition((((value & 8) != 0)) ? vdd : 0.0, 0, tr, tr);
        V(y[4]) <+ transition((((value & 16) != 0)) ? vdd : 0.0, 0, tr, tr);
        V(y[5]) <+ transition((((value & 32) != 0)) ? vdd : 0.0, 0, tr, tr);
        V(y[6]) <+ transition((((value & 64) != 0)) ? vdd : 0.0, 0, tr, tr);
        V(y[7]) <+ transition((((value & 128) != 0)) ? vdd : 0.0, 0, tr, tr);
    end
endmodule
