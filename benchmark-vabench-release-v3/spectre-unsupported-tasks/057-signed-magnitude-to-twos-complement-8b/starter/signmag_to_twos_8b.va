`include "constants.vams"
`include "disciplines.vams"

module signmag_to_twos_8b(
    input electrical sign,
    input electrical [6:0] mag,
    output electrical [7:0] y
);
    parameter real vdd = 0.9;
    parameter real vth = 0.45;
    parameter real tr = 20p;

    analog begin
        V(y[0]) <+ transition((0) ? vdd : 0.0, 0, tr, tr);
        V(y[1]) <+ transition((0) ? vdd : 0.0, 0, tr, tr);
        V(y[2]) <+ transition((0) ? vdd : 0.0, 0, tr, tr);
        V(y[3]) <+ transition((0) ? vdd : 0.0, 0, tr, tr);
        V(y[4]) <+ transition((0) ? vdd : 0.0, 0, tr, tr);
        V(y[5]) <+ transition((0) ? vdd : 0.0, 0, tr, tr);
        V(y[6]) <+ transition((0) ? vdd : 0.0, 0, tr, tr);
        V(y[7]) <+ transition((0) ? vdd : 0.0, 0, tr, tr);
    end
endmodule
