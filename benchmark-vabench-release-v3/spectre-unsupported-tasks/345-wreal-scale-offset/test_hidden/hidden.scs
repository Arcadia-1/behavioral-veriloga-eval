simulator lang=spectre
global 0

ahdl_include "wreal_scale_offset.vams"

Va (a 0) vsource type=pwl wave=[0 0.20 260n 0.20 261n 0.56 650n 0.56]
Vb (b 0) vsource type=pwl wave=[0 0.70 360n 0.70 361n 0.30 650n 0.30]
Vsel (sel 0) vsource type=pwl wave=[0 0.0 199n 0.0 200n 0.9 449n 0.9 450n 0.0 650n 0.0]

XDUT (a b sel y) wreal_scale_offset

tran tran stop=650n
save a b sel y
