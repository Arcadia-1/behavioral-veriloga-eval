`include "constants.vams"
`include "disciplines.vams"

module task_dual_output_update (
    input  electrical vin,
    input  electrical clk,
    input  electrical mode,
    input  electrical rst,
    output electrical out,
    output electrical metric
);
parameter real vth = 0.45;
parameter real vhi = 0.9;
parameter real tr = 200p;
real out_v;
real metric_v;
task update_outputs;
    input real sample;
    input real trim;
    real sum_v;
    real metric_raw;
    begin
        sum_v = sample + trim;
        if (sum_v < 0.0) out_v = 0.0;
        else if (sum_v > vhi) out_v = vhi;
        else out_v = sum_v;

        metric_raw = sample - trim + 0.3;
        if (metric_raw < 0.0) metric_raw = 0.0;
        else if (metric_raw > vhi) metric_raw = vhi;
        metric_v = metric_raw / vhi;
    end
endtask
analog begin
    @(initial_step) begin
        out_v = 0.0;
        metric_v = 0.0;
    end
    @(cross(V(clk) - vth, +1)) begin
        if (V(rst) > vth) begin
            out_v = 0.0;
            metric_v = 0.0;
        end else begin
            update_outputs(V(vin), V(mode));
        end
    end
    V(out) <+ transition(out_v, 0.0, tr, tr);
    V(metric) <+ transition(metric_v, 0.0, tr, tr);
end
endmodule
