module generate_genvar_replicated_stage(input a, output y);
    logic a, y;
    assign y = a;
endmodule
