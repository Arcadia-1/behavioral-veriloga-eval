`include "constants.vams"
`include "disciplines.vams"

module mixed_logic_clocked_voltage_sampler(vin, clk, en, sel, a, b, vout);
    input vin, clk, en, sel, a, b;
    output vout;
    electrical vin, vout;
    logic clk, en, sel;
    wreal a, b, level;
    logic sampled;
    logic sampled_next;
    parameter real tr = 200p;

    always @(posedge clk) begin
        sampled = sampled_next;
        sampled_next = en;
    end

    analog begin
        V(vout) <+ transition(sampled ? V(vin) : 0.0, 0.0, tr, tr);
    end
endmodule
