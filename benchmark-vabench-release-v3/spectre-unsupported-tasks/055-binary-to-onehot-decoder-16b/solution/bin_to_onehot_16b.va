`include "constants.vams"
`include "disciplines.vams"

module bin_to_onehot_16b(
    input electrical en,
    input electrical [3:0] b,
    output electrical [15:0] oh
);
    parameter real vdd = 0.9;
    parameter real vth = 0.45;
    parameter real tr = 20p;

    integer code;
    integer en_q;

    analog begin
        code = 0;
        if (V(b[0]) > vth) code = code + 1;
        if (V(b[1]) > vth) code = code + 2;
        if (V(b[2]) > vth) code = code + 4;
        if (V(b[3]) > vth) code = code + 8;
        en_q = (V(en) > vth) ? 1 : 0;
        V(oh[0]) <+ transition(((en_q != 0) && (0 == code)) ? vdd : 0.0, 0, tr, tr);
        V(oh[1]) <+ transition(((en_q != 0) && (1 == code)) ? vdd : 0.0, 0, tr, tr);
        V(oh[2]) <+ transition(((en_q != 0) && (2 == code)) ? vdd : 0.0, 0, tr, tr);
        V(oh[3]) <+ transition(((en_q != 0) && (3 == code)) ? vdd : 0.0, 0, tr, tr);
        V(oh[4]) <+ transition(((en_q != 0) && (4 == code)) ? vdd : 0.0, 0, tr, tr);
        V(oh[5]) <+ transition(((en_q != 0) && (5 == code)) ? vdd : 0.0, 0, tr, tr);
        V(oh[6]) <+ transition(((en_q != 0) && (6 == code)) ? vdd : 0.0, 0, tr, tr);
        V(oh[7]) <+ transition(((en_q != 0) && (7 == code)) ? vdd : 0.0, 0, tr, tr);
        V(oh[8]) <+ transition(((en_q != 0) && (8 == code)) ? vdd : 0.0, 0, tr, tr);
        V(oh[9]) <+ transition(((en_q != 0) && (9 == code)) ? vdd : 0.0, 0, tr, tr);
        V(oh[10]) <+ transition(((en_q != 0) && (10 == code)) ? vdd : 0.0, 0, tr, tr);
        V(oh[11]) <+ transition(((en_q != 0) && (11 == code)) ? vdd : 0.0, 0, tr, tr);
        V(oh[12]) <+ transition(((en_q != 0) && (12 == code)) ? vdd : 0.0, 0, tr, tr);
        V(oh[13]) <+ transition(((en_q != 0) && (13 == code)) ? vdd : 0.0, 0, tr, tr);
        V(oh[14]) <+ transition(((en_q != 0) && (14 == code)) ? vdd : 0.0, 0, tr, tr);
        V(oh[15]) <+ transition(((en_q != 0) && (15 == code)) ? vdd : 0.0, 0, tr, tr);
    end
endmodule
