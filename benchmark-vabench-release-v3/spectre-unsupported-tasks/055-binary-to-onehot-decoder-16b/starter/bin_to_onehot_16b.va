`include "constants.vams"
`include "disciplines.vams"

module bin_to_onehot_16b(
    input electrical en,
    input electrical [3:0] b,
    output electrical [15:0] oh
);
    parameter real vdd = 0.9;
    parameter real vth = 0.45;
    parameter real tr = 20p;
    genvar i;
    analog begin
        for (i = 0; i < 16; i = i + 1) V(oh[i]) <+ transition(0.0, 0, tr, tr);
    end
endmodule
