`include "constants.vams"
`include "disciplines.vams"

module bin_to_onehot_16b(
    input electrical en,
    input electrical [3:0] b,
    output electrical [15:0] oh
);
    parameter real vdd = 0.9;
    parameter real vth = 0.45;
    parameter real tr = 20p;

    analog begin
        V(oh[0]) <+ transition((0) ? vdd : 0.0, 0, tr, tr);
        V(oh[1]) <+ transition((0) ? vdd : 0.0, 0, tr, tr);
        V(oh[2]) <+ transition((0) ? vdd : 0.0, 0, tr, tr);
        V(oh[3]) <+ transition((0) ? vdd : 0.0, 0, tr, tr);
        V(oh[4]) <+ transition((0) ? vdd : 0.0, 0, tr, tr);
        V(oh[5]) <+ transition((0) ? vdd : 0.0, 0, tr, tr);
        V(oh[6]) <+ transition((0) ? vdd : 0.0, 0, tr, tr);
        V(oh[7]) <+ transition((0) ? vdd : 0.0, 0, tr, tr);
        V(oh[8]) <+ transition((0) ? vdd : 0.0, 0, tr, tr);
        V(oh[9]) <+ transition((0) ? vdd : 0.0, 0, tr, tr);
        V(oh[10]) <+ transition((0) ? vdd : 0.0, 0, tr, tr);
        V(oh[11]) <+ transition((0) ? vdd : 0.0, 0, tr, tr);
        V(oh[12]) <+ transition((0) ? vdd : 0.0, 0, tr, tr);
        V(oh[13]) <+ transition((0) ? vdd : 0.0, 0, tr, tr);
        V(oh[14]) <+ transition((0) ? vdd : 0.0, 0, tr, tr);
        V(oh[15]) <+ transition((0) ? vdd : 0.0, 0, tr, tr);
    end
endmodule
