module wreal_logic_threshold_bridge(ain, en, flag);
    input ain, en;
    output flag;
    wreal ain;
    logic en, flag;
    assign flag = en && (ain > 0.35);
endmodule
