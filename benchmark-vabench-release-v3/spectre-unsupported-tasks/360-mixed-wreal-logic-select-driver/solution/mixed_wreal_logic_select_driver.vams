`include "constants.vams"
`include "disciplines.vams"

module mixed_wreal_logic_select_driver(vin, clk, en, sel, a, b, vout);
    input vin, clk, en, sel, a, b;
    output vout;
    electrical vin, vout;
    logic clk, en, sel;
    wreal a, b, level;
    parameter real tr = 200p;

    assign level = sel ? a : b;

    analog begin
        V(vout) <+ transition(level, 0.0, tr, tr);
    end
endmodule
