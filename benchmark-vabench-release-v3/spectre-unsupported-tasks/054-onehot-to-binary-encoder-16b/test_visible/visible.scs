simulator lang=spectre
global 0

ahdl_include "onehot_to_bin_16b.va"

Voh0 (oh0 0) vsource type=pwl wave=[0 0.9 9.5n 0.9 10n 0 19.5n 0 20n 0 29.5n 0 30n 0 39.5n 0 40n 0 49.5n 0 50n 0 59.5n 0 60n 0 69.5n 0 70n 0 79.5n 0 80n 0 89.5n 0 90n 0 99.5n 0 100n 0 109.5n 0 110n 0 119.5n 0 120n 0 129.5n 0 130n 0 139.5n 0 140n 0 149.5n 0 150n 0 159.5n 0 160n 0 169.5n 0 170n 0 179.5n 0]
Voh1 (oh1 0) vsource type=pwl wave=[0 0 9.5n 0 10n 0.9 19.5n 0.9 20n 0 29.5n 0 30n 0 39.5n 0 40n 0 49.5n 0 50n 0 59.5n 0 60n 0 69.5n 0 70n 0 79.5n 0 80n 0 89.5n 0 90n 0 99.5n 0 100n 0 109.5n 0 110n 0 119.5n 0 120n 0 129.5n 0 130n 0 139.5n 0 140n 0 149.5n 0 150n 0 159.5n 0 160n 0 169.5n 0 170n 0.9 179.5n 0.9]
Voh2 (oh2 0) vsource type=pwl wave=[0 0 9.5n 0 10n 0 19.5n 0 20n 0.9 29.5n 0.9 30n 0 39.5n 0 40n 0 49.5n 0 50n 0 59.5n 0 60n 0 69.5n 0 70n 0 79.5n 0 80n 0 89.5n 0 90n 0 99.5n 0 100n 0 109.5n 0 110n 0 119.5n 0 120n 0 129.5n 0 130n 0 139.5n 0 140n 0 149.5n 0 150n 0 159.5n 0 160n 0 169.5n 0 170n 0 179.5n 0]
Voh3 (oh3 0) vsource type=pwl wave=[0 0 9.5n 0 10n 0 19.5n 0 20n 0 29.5n 0 30n 0.9 39.5n 0.9 40n 0 49.5n 0 50n 0 59.5n 0 60n 0 69.5n 0 70n 0 79.5n 0 80n 0 89.5n 0 90n 0 99.5n 0 100n 0 109.5n 0 110n 0 119.5n 0 120n 0 129.5n 0 130n 0 139.5n 0 140n 0 149.5n 0 150n 0 159.5n 0 160n 0 169.5n 0 170n 0.9 179.5n 0.9]
Voh4 (oh4 0) vsource type=pwl wave=[0 0 9.5n 0 10n 0 19.5n 0 20n 0 29.5n 0 30n 0 39.5n 0 40n 0.9 49.5n 0.9 50n 0 59.5n 0 60n 0 69.5n 0 70n 0 79.5n 0 80n 0 89.5n 0 90n 0 99.5n 0 100n 0 109.5n 0 110n 0 119.5n 0 120n 0 129.5n 0 130n 0 139.5n 0 140n 0 149.5n 0 150n 0 159.5n 0 160n 0 169.5n 0 170n 0 179.5n 0]
Voh5 (oh5 0) vsource type=pwl wave=[0 0 9.5n 0 10n 0 19.5n 0 20n 0 29.5n 0 30n 0 39.5n 0 40n 0 49.5n 0 50n 0.9 59.5n 0.9 60n 0 69.5n 0 70n 0 79.5n 0 80n 0 89.5n 0 90n 0 99.5n 0 100n 0 109.5n 0 110n 0 119.5n 0 120n 0 129.5n 0 130n 0 139.5n 0 140n 0 149.5n 0 150n 0 159.5n 0 160n 0 169.5n 0 170n 0 179.5n 0]
Voh6 (oh6 0) vsource type=pwl wave=[0 0 9.5n 0 10n 0 19.5n 0 20n 0 29.5n 0 30n 0 39.5n 0 40n 0 49.5n 0 50n 0 59.5n 0 60n 0.9 69.5n 0.9 70n 0 79.5n 0 80n 0 89.5n 0 90n 0 99.5n 0 100n 0 109.5n 0 110n 0 119.5n 0 120n 0 129.5n 0 130n 0 139.5n 0 140n 0 149.5n 0 150n 0 159.5n 0 160n 0 169.5n 0 170n 0 179.5n 0]
Voh7 (oh7 0) vsource type=pwl wave=[0 0 9.5n 0 10n 0 19.5n 0 20n 0 29.5n 0 30n 0 39.5n 0 40n 0 49.5n 0 50n 0 59.5n 0 60n 0 69.5n 0 70n 0.9 79.5n 0.9 80n 0 89.5n 0 90n 0 99.5n 0 100n 0 109.5n 0 110n 0 119.5n 0 120n 0 129.5n 0 130n 0 139.5n 0 140n 0 149.5n 0 150n 0 159.5n 0 160n 0 169.5n 0 170n 0 179.5n 0]
Voh8 (oh8 0) vsource type=pwl wave=[0 0 9.5n 0 10n 0 19.5n 0 20n 0 29.5n 0 30n 0 39.5n 0 40n 0 49.5n 0 50n 0 59.5n 0 60n 0 69.5n 0 70n 0 79.5n 0 80n 0.9 89.5n 0.9 90n 0 99.5n 0 100n 0 109.5n 0 110n 0 119.5n 0 120n 0 129.5n 0 130n 0 139.5n 0 140n 0 149.5n 0 150n 0 159.5n 0 160n 0 169.5n 0 170n 0 179.5n 0]
Voh9 (oh9 0) vsource type=pwl wave=[0 0 9.5n 0 10n 0 19.5n 0 20n 0 29.5n 0 30n 0 39.5n 0 40n 0 49.5n 0 50n 0 59.5n 0 60n 0 69.5n 0 70n 0 79.5n 0 80n 0 89.5n 0 90n 0.9 99.5n 0.9 100n 0 109.5n 0 110n 0 119.5n 0 120n 0 129.5n 0 130n 0 139.5n 0 140n 0 149.5n 0 150n 0 159.5n 0 160n 0 169.5n 0 170n 0 179.5n 0]
Voh10 (oh10 0) vsource type=pwl wave=[0 0 9.5n 0 10n 0 19.5n 0 20n 0 29.5n 0 30n 0 39.5n 0 40n 0 49.5n 0 50n 0 59.5n 0 60n 0 69.5n 0 70n 0 79.5n 0 80n 0 89.5n 0 90n 0 99.5n 0 100n 0.9 109.5n 0.9 110n 0 119.5n 0 120n 0 129.5n 0 130n 0 139.5n 0 140n 0 149.5n 0 150n 0 159.5n 0 160n 0 169.5n 0 170n 0 179.5n 0]
Voh11 (oh11 0) vsource type=pwl wave=[0 0 9.5n 0 10n 0 19.5n 0 20n 0 29.5n 0 30n 0 39.5n 0 40n 0 49.5n 0 50n 0 59.5n 0 60n 0 69.5n 0 70n 0 79.5n 0 80n 0 89.5n 0 90n 0 99.5n 0 100n 0 109.5n 0 110n 0.9 119.5n 0.9 120n 0 129.5n 0 130n 0 139.5n 0 140n 0 149.5n 0 150n 0 159.5n 0 160n 0 169.5n 0 170n 0 179.5n 0]
Voh12 (oh12 0) vsource type=pwl wave=[0 0 9.5n 0 10n 0 19.5n 0 20n 0 29.5n 0 30n 0 39.5n 0 40n 0 49.5n 0 50n 0 59.5n 0 60n 0 69.5n 0 70n 0 79.5n 0 80n 0 89.5n 0 90n 0 99.5n 0 100n 0 109.5n 0 110n 0 119.5n 0 120n 0.9 129.5n 0.9 130n 0 139.5n 0 140n 0 149.5n 0 150n 0 159.5n 0 160n 0 169.5n 0 170n 0 179.5n 0]
Voh13 (oh13 0) vsource type=pwl wave=[0 0 9.5n 0 10n 0 19.5n 0 20n 0 29.5n 0 30n 0 39.5n 0 40n 0 49.5n 0 50n 0 59.5n 0 60n 0 69.5n 0 70n 0 79.5n 0 80n 0 89.5n 0 90n 0 99.5n 0 100n 0 109.5n 0 110n 0 119.5n 0 120n 0 129.5n 0 130n 0.9 139.5n 0.9 140n 0 149.5n 0 150n 0 159.5n 0 160n 0 169.5n 0 170n 0 179.5n 0]
Voh14 (oh14 0) vsource type=pwl wave=[0 0 9.5n 0 10n 0 19.5n 0 20n 0 29.5n 0 30n 0 39.5n 0 40n 0 49.5n 0 50n 0 59.5n 0 60n 0 69.5n 0 70n 0 79.5n 0 80n 0 89.5n 0 90n 0 99.5n 0 100n 0 109.5n 0 110n 0 119.5n 0 120n 0 129.5n 0 130n 0 139.5n 0 140n 0.9 149.5n 0.9 150n 0 159.5n 0 160n 0 169.5n 0 170n 0 179.5n 0]
Voh15 (oh15 0) vsource type=pwl wave=[0 0 9.5n 0 10n 0 19.5n 0 20n 0 29.5n 0 30n 0 39.5n 0 40n 0 49.5n 0 50n 0 59.5n 0 60n 0 69.5n 0 70n 0 79.5n 0 80n 0 89.5n 0 90n 0 99.5n 0 100n 0 109.5n 0 110n 0 119.5n 0 120n 0 129.5n 0 130n 0 139.5n 0 140n 0 149.5n 0 150n 0.9 159.5n 0.9 160n 0 169.5n 0 170n 0 179.5n 0]

XDUT (oh15 oh14 oh13 oh12 oh11 oh10 oh9 oh8 oh7 oh6 oh5 oh4 oh3 oh2 oh1 oh0 b3 b2 b1 b0 valid) onehot_to_bin_16b

tran tran stop=185n maxstep=100p
save valid oh0 oh1 oh2 oh3 oh4 oh5 oh6 oh7 oh8 oh9 oh10 oh11 oh12 oh13 oh14 oh15 b0 b1 b2 b3
