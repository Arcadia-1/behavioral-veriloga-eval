`include "constants.vams"
`include "disciplines.vams"

module onehot_to_bin_16b(
    input electrical [15:0] oh,
    output electrical [3:0] b,
    output electrical valid
);
    parameter real vdd = 0.9;
    parameter real vth = 0.45;
    parameter real tr = 20p;

    analog begin
        V(b[0]) <+ transition((0) ? vdd : 0.0, 0, tr, tr);
        V(b[1]) <+ transition((0) ? vdd : 0.0, 0, tr, tr);
        V(b[2]) <+ transition((0) ? vdd : 0.0, 0, tr, tr);
        V(b[3]) <+ transition((0) ? vdd : 0.0, 0, tr, tr);
        V(valid) <+ transition(0.0, 0, tr, tr);
    end
endmodule
