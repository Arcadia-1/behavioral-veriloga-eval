`include "constants.vams"
`include "disciplines.vams"

module onehot_to_bin_16b(
    input electrical [15:0] oh,
    output electrical [3:0] b,
    output electrical valid
);
    parameter real vdd = 0.9;
    parameter real vth = 0.45;
    parameter real tr = 20p;

    integer count;
    integer idx;
    integer index;
    integer j;
    genvar i;

    analog begin
        count = 0;
        idx = 0;
        for (j = 0; j < 16; j = j + 1) begin
            if (V(oh[j]) > vth) begin
                count = count + 1;
                idx = j;
            end
        end
        index = (count == 1) ? idx : 0;
        for (i = 0; i < 4; i = i + 1) begin
            V(b[i]) <+ transition((((index / (1 << i)) % 2) != 0) ? vdd : 0.0, 0, tr, tr);
        end
        V(valid) <+ transition((count == 1) ? vdd : 0.0, 0, tr, tr);
    end
endmodule
