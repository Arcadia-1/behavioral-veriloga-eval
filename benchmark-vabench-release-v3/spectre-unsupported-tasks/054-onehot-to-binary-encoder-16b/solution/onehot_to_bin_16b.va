`include "constants.vams"
`include "disciplines.vams"

module onehot_to_bin_16b(
    input electrical [15:0] oh,
    output electrical [3:0] b,
    output electrical valid
);
    parameter real vdd = 0.9;
    parameter real vth = 0.45;
    parameter real tr = 20p;

    integer count;
    integer idx;
    integer index;

    analog begin
        count = 0;
        idx = 0;
        if (V(oh[0]) > vth) begin
            count = count + 1;
            idx = 0;
        end
        if (V(oh[1]) > vth) begin
            count = count + 1;
            idx = 1;
        end
        if (V(oh[2]) > vth) begin
            count = count + 1;
            idx = 2;
        end
        if (V(oh[3]) > vth) begin
            count = count + 1;
            idx = 3;
        end
        if (V(oh[4]) > vth) begin
            count = count + 1;
            idx = 4;
        end
        if (V(oh[5]) > vth) begin
            count = count + 1;
            idx = 5;
        end
        if (V(oh[6]) > vth) begin
            count = count + 1;
            idx = 6;
        end
        if (V(oh[7]) > vth) begin
            count = count + 1;
            idx = 7;
        end
        if (V(oh[8]) > vth) begin
            count = count + 1;
            idx = 8;
        end
        if (V(oh[9]) > vth) begin
            count = count + 1;
            idx = 9;
        end
        if (V(oh[10]) > vth) begin
            count = count + 1;
            idx = 10;
        end
        if (V(oh[11]) > vth) begin
            count = count + 1;
            idx = 11;
        end
        if (V(oh[12]) > vth) begin
            count = count + 1;
            idx = 12;
        end
        if (V(oh[13]) > vth) begin
            count = count + 1;
            idx = 13;
        end
        if (V(oh[14]) > vth) begin
            count = count + 1;
            idx = 14;
        end
        if (V(oh[15]) > vth) begin
            count = count + 1;
            idx = 15;
        end
        index = (count == 1) ? idx : 0;
        V(b[0]) <+ transition((((index & 1) != 0)) ? vdd : 0.0, 0, tr, tr);
        V(b[1]) <+ transition((((index & 2) != 0)) ? vdd : 0.0, 0, tr, tr);
        V(b[2]) <+ transition((((index & 4) != 0)) ? vdd : 0.0, 0, tr, tr);
        V(b[3]) <+ transition((((index & 8) != 0)) ? vdd : 0.0, 0, tr, tr);
        V(valid) <+ transition((count == 1) ? vdd : 0.0, 0, tr, tr);
    end
endmodule
