module always_async_reset_counter(clk, rst, en, q);
    input clk, rst, en;
    output q;
    logic clk, rst, en;
    logic q;
    always @(posedge clk or posedge rst) begin
        if (rst) q = 1'b0;
        else if (en) q = ~q;
    end
endmodule
