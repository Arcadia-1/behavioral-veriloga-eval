module always_posedged_dff(clk, rst, d, en, q);
    input clk, rst, d, en;
    output q;
    logic clk, rst, d, en, q;

    always @(posedge clk) begin
        if (en) q = d;
        else q = q;
    end
endmodule
