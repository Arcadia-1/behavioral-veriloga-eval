simulator lang=spectre
global 0
ahdl_include "../solution/connectmodule_electrical_bridge.vams"

Va (a 0) vsource type=pwl wave=[0n 0.65 18n 0.2 48n 0.85 95n 0.1 140n 0.5]
Xdut (a y) connectmodule_electrical_bridge gain=1.0

tran tran stop=160n
save a y
