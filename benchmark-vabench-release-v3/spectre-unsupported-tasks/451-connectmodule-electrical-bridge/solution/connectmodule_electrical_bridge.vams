connectmodule connectmodule_electrical_bridge(input electrical a, output electrical y);
    parameter real gain = 1.0;
    analog begin
        V(y) <+ gain * V(a);
    end
endconnectmodule
