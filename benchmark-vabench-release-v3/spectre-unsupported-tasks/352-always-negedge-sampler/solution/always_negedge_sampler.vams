module always_negedge_sampler(clk, rst, d, en, q);
    input clk, rst, d, en;
    output q;
    logic clk, rst, d, en, q;

    always @(negedge clk) begin
        if (rst) q = 1'b0;
        else if (en) q = d;
        else q = q;
    end
endmodule
