simulator lang=spectre
global 0

ahdl_include "always_negedge_sampler.vams"

Vclk (clk 0) vsource type=pwl wave=[0 1.0 59n 1.0 60n 0.0 99n 0.0 100n 1.0 159n 1.0 160n 0.0 199n 0.0 200n 1.0 259n 1.0 260n 0.0 299n 0.0 300n 1.0 359n 1.0 360n 0.0 399n 0.0 400n 1.0 459n 1.0 460n 0.0 499n 0.0 500n 1.0 559n 1.0 560n 0.0 599n 0.0 600n 1.0 659n 1.0 660n 0.0 720n 0.0]
Vrst (rst 0) vsource type=pwl wave=[0 1.0 89n 1.0 90n 0.0 720n 0.0]
Vd (d 0) vsource type=pwl wave=[0 1.0 319n 1.0 320n 0.0 519n 0.0 520n 1.0 720n 1.0]
Ven (en 0) vsource type=pwl wave=[0 1.0 219n 1.0 220n 0.0 339n 0.0 340n 1.0 479n 1.0 480n 0.0 599n 0.0 600n 1.0 720n 1.0]

XDUT (clk rst d en q) always_negedge_sampler

tran tran stop=720n
save clk rst d en q
