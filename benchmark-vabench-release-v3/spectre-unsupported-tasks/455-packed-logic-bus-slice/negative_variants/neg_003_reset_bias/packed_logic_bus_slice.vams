module packed_logic_bus_slice(input [7:0] a, output [3:0] y);
    logic [7:0] a;
    logic [3:0] y;
    assign y = {a[6:5], a[1:0]};
endmodule
