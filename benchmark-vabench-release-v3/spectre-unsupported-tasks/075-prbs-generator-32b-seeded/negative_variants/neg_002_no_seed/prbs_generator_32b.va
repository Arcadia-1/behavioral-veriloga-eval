`include "constants.vams"
`include "disciplines.vams"

module prbs_generator_32b(
    input electrical clk,
    input electrical rst,
    input electrical load_seed,
    input electrical [0:31] seed,
    output electrical [0:31] out
);
    parameter real vdd = 0.9;
    parameter real vth = 0.45;
    parameter real tr = 20p;

    integer state[0:31];
    integer feedback;
    integer any_seed;

    analog begin
        @(initial_step) begin
            state[0] = 1;
            state[1] = 0;
            state[2] = 0;
            state[3] = 0;
            state[4] = 0;
            state[5] = 0;
            state[6] = 0;
            state[7] = 0;
            state[8] = 0;
            state[9] = 0;
            state[10] = 0;
            state[11] = 0;
            state[12] = 0;
            state[13] = 0;
            state[14] = 0;
            state[15] = 0;
            state[16] = 0;
            state[17] = 0;
            state[18] = 0;
            state[19] = 0;
            state[20] = 0;
            state[21] = 0;
            state[22] = 0;
            state[23] = 0;
            state[24] = 0;
            state[25] = 0;
            state[26] = 0;
            state[27] = 0;
            state[28] = 0;
            state[29] = 0;
            state[30] = 0;
            state[31] = 0;
        end

        @(cross(V(clk) - vth, +1)) begin
            if (V(rst) > vth) begin
                state[0] = 1;
                state[1] = 0;
                state[2] = 0;
                state[3] = 0;
                state[4] = 0;
                state[5] = 0;
                state[6] = 0;
                state[7] = 0;
                state[8] = 0;
                state[9] = 0;
                state[10] = 0;
                state[11] = 0;
                state[12] = 0;
                state[13] = 0;
                state[14] = 0;
                state[15] = 0;
                state[16] = 0;
                state[17] = 0;
                state[18] = 0;
                state[19] = 0;
                state[20] = 0;
                state[21] = 0;
                state[22] = 0;
                state[23] = 0;
                state[24] = 0;
                state[25] = 0;
                state[26] = 0;
                state[27] = 0;
                state[28] = 0;
                state[29] = 0;
                state[30] = 0;
                state[31] = 0;
            end else begin
                feedback = (state[31] ^ state[21] ^ state[1] ^ state[0]) & 1;
                state[31] = state[30];
                state[30] = state[29];
                state[29] = state[28];
                state[28] = state[27];
                state[27] = state[26];
                state[26] = state[25];
                state[25] = state[24];
                state[24] = state[23];
                state[23] = state[22];
                state[22] = state[21];
                state[21] = state[20];
                state[20] = state[19];
                state[19] = state[18];
                state[18] = state[17];
                state[17] = state[16];
                state[16] = state[15];
                state[15] = state[14];
                state[14] = state[13];
                state[13] = state[12];
                state[12] = state[11];
                state[11] = state[10];
                state[10] = state[9];
                state[9] = state[8];
                state[8] = state[7];
                state[7] = state[6];
                state[6] = state[5];
                state[5] = state[4];
                state[4] = state[3];
                state[3] = state[2];
                state[2] = state[1];
                state[1] = state[0];
                state[0] = feedback;
            end
        end

        V(out[0]) <+ transition((state[0]) ? vdd : 0.0, 0, tr, tr);
        V(out[1]) <+ transition((state[1]) ? vdd : 0.0, 0, tr, tr);
        V(out[2]) <+ transition((state[2]) ? vdd : 0.0, 0, tr, tr);
        V(out[3]) <+ transition((state[3]) ? vdd : 0.0, 0, tr, tr);
        V(out[4]) <+ transition((state[4]) ? vdd : 0.0, 0, tr, tr);
        V(out[5]) <+ transition((state[5]) ? vdd : 0.0, 0, tr, tr);
        V(out[6]) <+ transition((state[6]) ? vdd : 0.0, 0, tr, tr);
        V(out[7]) <+ transition((state[7]) ? vdd : 0.0, 0, tr, tr);
        V(out[8]) <+ transition((state[8]) ? vdd : 0.0, 0, tr, tr);
        V(out[9]) <+ transition((state[9]) ? vdd : 0.0, 0, tr, tr);
        V(out[10]) <+ transition((state[10]) ? vdd : 0.0, 0, tr, tr);
        V(out[11]) <+ transition((state[11]) ? vdd : 0.0, 0, tr, tr);
        V(out[12]) <+ transition((state[12]) ? vdd : 0.0, 0, tr, tr);
        V(out[13]) <+ transition((state[13]) ? vdd : 0.0, 0, tr, tr);
        V(out[14]) <+ transition((state[14]) ? vdd : 0.0, 0, tr, tr);
        V(out[15]) <+ transition((state[15]) ? vdd : 0.0, 0, tr, tr);
        V(out[16]) <+ transition((state[16]) ? vdd : 0.0, 0, tr, tr);
        V(out[17]) <+ transition((state[17]) ? vdd : 0.0, 0, tr, tr);
        V(out[18]) <+ transition((state[18]) ? vdd : 0.0, 0, tr, tr);
        V(out[19]) <+ transition((state[19]) ? vdd : 0.0, 0, tr, tr);
        V(out[20]) <+ transition((state[20]) ? vdd : 0.0, 0, tr, tr);
        V(out[21]) <+ transition((state[21]) ? vdd : 0.0, 0, tr, tr);
        V(out[22]) <+ transition((state[22]) ? vdd : 0.0, 0, tr, tr);
        V(out[23]) <+ transition((state[23]) ? vdd : 0.0, 0, tr, tr);
        V(out[24]) <+ transition((state[24]) ? vdd : 0.0, 0, tr, tr);
        V(out[25]) <+ transition((state[25]) ? vdd : 0.0, 0, tr, tr);
        V(out[26]) <+ transition((state[26]) ? vdd : 0.0, 0, tr, tr);
        V(out[27]) <+ transition((state[27]) ? vdd : 0.0, 0, tr, tr);
        V(out[28]) <+ transition((state[28]) ? vdd : 0.0, 0, tr, tr);
        V(out[29]) <+ transition((state[29]) ? vdd : 0.0, 0, tr, tr);
        V(out[30]) <+ transition((state[30]) ? vdd : 0.0, 0, tr, tr);
        V(out[31]) <+ transition((state[31]) ? vdd : 0.0, 0, tr, tr);
    end
endmodule
