module logic_vector_reduction_flag(input [3:0] code, output valid);
    logic [3:0] code;
    logic valid;
    assign valid = code[0] | code[1] | code[2];
endmodule
