`include "constants.vams"
`include "disciplines.vams"

module gray_to_bin_8b(
    input electrical [7:0] g,
    output electrical [7:0] b
);
    parameter real vdd = 0.9;
    parameter real vth = 0.45;
    parameter real tr = 20p;

    integer g7_q, g6_q, g5_q, g4_q, g3_q, g2_q, g1_q, g0_q;
    integer b7_q, b6_q, b5_q, b4_q, b3_q, b2_q, b1_q, b0_q;

    analog begin
        g7_q = (V(g[7]) > vth) ? 1 : 0;
        g6_q = (V(g[6]) > vth) ? 1 : 0;
        g5_q = (V(g[5]) > vth) ? 1 : 0;
        g4_q = (V(g[4]) > vth) ? 1 : 0;
        g3_q = (V(g[3]) > vth) ? 1 : 0;
        g2_q = (V(g[2]) > vth) ? 1 : 0;
        g1_q = (V(g[1]) > vth) ? 1 : 0;
        g0_q = (V(g[0]) > vth) ? 1 : 0;

        b7_q = g7_q;
        b6_q = (b7_q != g6_q) ? 1 : 0;
        b5_q = (b6_q != g5_q) ? 1 : 0;
        b4_q = (b5_q != g4_q) ? 1 : 0;
        b3_q = (b4_q != g3_q) ? 1 : 0;
        b2_q = (b3_q != g2_q) ? 1 : 0;
        b1_q = (b2_q != g1_q) ? 1 : 0;
        b0_q = (b1_q != g0_q) ? 1 : 0;

        V(b[7]) <+ transition(b7_q ? vdd : 0.0, 0, tr, tr);
        V(b[6]) <+ transition(b6_q ? vdd : 0.0, 0, tr, tr);
        V(b[5]) <+ transition(b5_q ? vdd : 0.0, 0, tr, tr);
        V(b[4]) <+ transition(b4_q ? vdd : 0.0, 0, tr, tr);
        V(b[3]) <+ transition(b3_q ? vdd : 0.0, 0, tr, tr);
        V(b[2]) <+ transition(b2_q ? vdd : 0.0, 0, tr, tr);
        V(b[1]) <+ transition(b1_q ? vdd : 0.0, 0, tr, tr);
        V(b[0]) <+ transition(b0_q ? vdd : 0.0, 0, tr, tr);
    end
endmodule
