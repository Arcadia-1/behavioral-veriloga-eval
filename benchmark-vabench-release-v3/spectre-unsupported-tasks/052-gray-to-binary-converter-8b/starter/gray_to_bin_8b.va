`include "constants.vams"
`include "disciplines.vams"

module gray_to_bin_8b(
    input electrical [7:0] g,
    output electrical [7:0] b
);
    parameter real vdd = 0.9;
    parameter real vth = 0.45;
    parameter real tr = 20p;
    analog begin
        V(b[7]) <+ transition(0.0, 0, tr, tr);
        V(b[6]) <+ transition(0.0, 0, tr, tr);
        V(b[5]) <+ transition(0.0, 0, tr, tr);
        V(b[4]) <+ transition(0.0, 0, tr, tr);
        V(b[3]) <+ transition(0.0, 0, tr, tr);
        V(b[2]) <+ transition(0.0, 0, tr, tr);
        V(b[1]) <+ transition(0.0, 0, tr, tr);
        V(b[0]) <+ transition(0.0, 0, tr, tr);
    end
endmodule
