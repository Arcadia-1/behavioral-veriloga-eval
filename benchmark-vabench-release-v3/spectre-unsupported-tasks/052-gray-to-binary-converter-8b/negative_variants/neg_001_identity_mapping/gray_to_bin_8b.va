`include "constants.vams"
`include "disciplines.vams"

module gray_to_bin_8b(
    input electrical [7:0] g,
    output electrical [7:0] b
);
    parameter real vdd = 0.9;
    parameter real vth = 0.45;
    parameter real tr = 20p;

    integer g7_q, g6_q, g5_q, g4_q, g3_q, g2_q, g1_q, g0_q;

    analog begin
        g7_q = (V(g[7]) > vth) ? 1 : 0;
        g6_q = (V(g[6]) > vth) ? 1 : 0;
        g5_q = (V(g[5]) > vth) ? 1 : 0;
        g4_q = (V(g[4]) > vth) ? 1 : 0;
        g3_q = (V(g[3]) > vth) ? 1 : 0;
        g2_q = (V(g[2]) > vth) ? 1 : 0;
        g1_q = (V(g[1]) > vth) ? 1 : 0;
        g0_q = (V(g[0]) > vth) ? 1 : 0;

        V(b[7]) <+ transition(g7_q ? vdd : 0.0, 0, tr, tr);
        V(b[6]) <+ transition(g6_q ? vdd : 0.0, 0, tr, tr);
        V(b[5]) <+ transition(g5_q ? vdd : 0.0, 0, tr, tr);
        V(b[4]) <+ transition(g4_q ? vdd : 0.0, 0, tr, tr);
        V(b[3]) <+ transition(g3_q ? vdd : 0.0, 0, tr, tr);
        V(b[2]) <+ transition(g2_q ? vdd : 0.0, 0, tr, tr);
        V(b[1]) <+ transition(g1_q ? vdd : 0.0, 0, tr, tr);
        V(b[0]) <+ transition(g0_q ? vdd : 0.0, 0, tr, tr);
    end
endmodule
