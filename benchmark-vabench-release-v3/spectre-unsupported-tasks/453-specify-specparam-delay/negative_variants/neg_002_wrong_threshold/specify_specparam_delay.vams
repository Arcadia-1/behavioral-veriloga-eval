module specify_specparam_delay(input a, output y);
    logic a, y;
    assign y = a;
    specify
        specparam tpd = 2n;
        (a => y) = tpd;
    endspecify
endmodule
