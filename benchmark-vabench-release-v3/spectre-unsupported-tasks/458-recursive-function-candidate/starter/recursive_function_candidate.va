`include "constants.vams"
`include "disciplines.vams"

module recursive_function_candidate(output electrical out);
parameter integer depth = 3 from [1:5];

function real fact;
    input integer n;
    begin
        fact = 1.0;
    end
endfunction

analog begin
    V(out) <+ fact(depth);
end

endmodule
