`include "constants.vams"
`include "disciplines.vams"

module decimal_to_bcd(
    input electrical [9:0] d,
    output electrical [3:0] b,
    output electrical valid
);
    parameter real vdd = 0.9;
    parameter real vth = 0.45;
    parameter real tr = 20p;

    integer count;
    integer digit;
    integer code;

    analog begin
        count = 0;
        digit = 0;
        if (V(d[0]) > vth) begin
            count = count + 1;
            digit = 0;
        end
        if (V(d[1]) > vth) begin
            count = count + 1;
            digit = 1;
        end
        if (V(d[2]) > vth) begin
            count = count + 1;
            digit = 2;
        end
        if (V(d[3]) > vth) begin
            count = count + 1;
            digit = 3;
        end
        if (V(d[4]) > vth) begin
            count = count + 1;
            digit = 4;
        end
        if (V(d[5]) > vth) begin
            count = count + 1;
            digit = 5;
        end
        if (V(d[6]) > vth) begin
            count = count + 1;
            digit = 6;
        end
        if (V(d[7]) > vth) begin
            count = count + 1;
            digit = 7;
        end
        if (V(d[8]) > vth) begin
            count = count + 1;
            digit = 8;
        end
        if (V(d[9]) > vth) begin
            count = count + 1;
            digit = 9;
        end
        code = (count == 1) ? digit : 0;
        V(b[0]) <+ transition((((code & 1) != 0)) ? vdd : 0.0, 0, tr, tr);
        V(b[1]) <+ transition((((code & 2) != 0)) ? vdd : 0.0, 0, tr, tr);
        V(b[2]) <+ transition((((code & 4) != 0)) ? vdd : 0.0, 0, tr, tr);
        V(b[3]) <+ transition((((code & 8) != 0)) ? vdd : 0.0, 0, tr, tr);
        V(valid) <+ transition((count == 1) ? vdd : 0.0, 0, tr, tr);
    end
endmodule
