`include "constants.vams"
`include "disciplines.vams"

module decimal_to_bcd(
    input electrical [9:0] d,
    output electrical [3:0] b,
    output electrical valid
);
    parameter real vdd = 0.9;
    parameter real vth = 0.45;
    parameter real tr = 20p;

    integer count;
    integer digit;
    integer code;
    integer j;
    genvar i;

    analog begin
        count = 0;
        digit = 0;
        for (j = 0; j < 10; j = j + 1) begin
            if (V(d[j]) > vth) begin
                count = count + 1;
                digit = j;
            end
        end
        code = (count == 1) ? digit : 0;
        for (i = 0; i < 4; i = i + 1) begin
            V(b[i]) <+ transition((((code / (1 << i)) % 2) != 0) ? vdd : 0.0, 0, tr, tr);
        end
        V(valid) <+ transition((count == 1) ? vdd : 0.0, 0, tr, tr);
    end
endmodule
