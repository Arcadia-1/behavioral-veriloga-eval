`include "constants.vams"
`include "disciplines.vams"

module task_local_variable_transform (
    input  electrical vin,
    input  electrical clk,
    input  electrical mode,
    input  electrical rst,
    output electrical out,
    output electrical metric
);
parameter real vth = 0.45;
parameter real vhi = 0.9;
parameter real tr = 200p;
real out_v;
real metric_v;
integer count_q;
task update_with_local;
    input real sample;
    real clipped;
    begin
        clipped = sample < 0.0 ? 0.0 : (sample > 0.9 ? 0.9 : sample);
        out_v = clipped;
        metric_v = clipped / 0.9;
    end
endtask

analog begin
    @(initial_step) begin
        out_v = 0.0;
        metric_v = 0.0;
        count_q = 0;
    end
    @(cross(V(clk) - vth, +1)) begin
        if (V(rst) > vth) begin
            out_v = 0.0;
            metric_v = 0.0;
            count_q = 0;
        end else begin
            update_with_local(V(vin));
            count_q = count_q + 1;
        end
    end
    V(out) <+ transition(out_v, 0.0, tr, tr);
    V(metric) <+ transition(metric_v, 0.0, tr, tr);
end
endmodule
