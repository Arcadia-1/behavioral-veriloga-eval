simulator lang=spectre
global 0

ahdl_include "wreal_threshold_flag.vams"

Va (a 0) vsource type=pwl wave=[0 0.32 220n 0.32 221n 0.41 420n 0.41 421n 0.52 650n 0.52]
Vb (b 0) vsource dc=0.0 type=dc
Vsel (sel 0) vsource type=pwl wave=[0 0.0 199n 0.0 200n 0.9 449n 0.9 450n 0.0 650n 0.0]

XDUT (a b sel y) wreal_threshold_flag

tran tran stop=650n
save a b sel y
