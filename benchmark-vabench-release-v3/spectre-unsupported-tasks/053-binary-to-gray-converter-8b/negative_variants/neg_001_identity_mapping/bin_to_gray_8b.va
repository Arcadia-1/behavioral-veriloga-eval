`include "constants.vams"
`include "disciplines.vams"

module bin_to_gray_8b(
    input electrical [7:0] b,
    output electrical [7:0] g
);
    parameter real vdd = 0.9;
    parameter real vth = 0.45;
    parameter real tr = 20p;

    integer b7_q, b6_q, b5_q, b4_q, b3_q, b2_q, b1_q, b0_q;

    analog begin
        b7_q = (V(b[7]) > vth) ? 1 : 0;
        b6_q = (V(b[6]) > vth) ? 1 : 0;
        b5_q = (V(b[5]) > vth) ? 1 : 0;
        b4_q = (V(b[4]) > vth) ? 1 : 0;
        b3_q = (V(b[3]) > vth) ? 1 : 0;
        b2_q = (V(b[2]) > vth) ? 1 : 0;
        b1_q = (V(b[1]) > vth) ? 1 : 0;
        b0_q = (V(b[0]) > vth) ? 1 : 0;

        V(g[7]) <+ transition(b7_q ? vdd : 0.0, 0, tr, tr);
        V(g[6]) <+ transition(b6_q ? vdd : 0.0, 0, tr, tr);
        V(g[5]) <+ transition(b5_q ? vdd : 0.0, 0, tr, tr);
        V(g[4]) <+ transition(b4_q ? vdd : 0.0, 0, tr, tr);
        V(g[3]) <+ transition(b3_q ? vdd : 0.0, 0, tr, tr);
        V(g[2]) <+ transition(b2_q ? vdd : 0.0, 0, tr, tr);
        V(g[1]) <+ transition(b1_q ? vdd : 0.0, 0, tr, tr);
        V(g[0]) <+ transition(b0_q ? vdd : 0.0, 0, tr, tr);
    end
endmodule
