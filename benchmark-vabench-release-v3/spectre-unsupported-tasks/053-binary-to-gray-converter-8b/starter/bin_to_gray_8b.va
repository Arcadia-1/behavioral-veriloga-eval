`include "constants.vams"
`include "disciplines.vams"

module bin_to_gray_8b(
    input electrical [7:0] b,
    output electrical [7:0] g
);
    parameter real vdd = 0.9;
    parameter real vth = 0.45;
    parameter real tr = 20p;
    analog begin
        V(g[7]) <+ transition(0.0, 0, tr, tr);
        V(g[6]) <+ transition(0.0, 0, tr, tr);
        V(g[5]) <+ transition(0.0, 0, tr, tr);
        V(g[4]) <+ transition(0.0, 0, tr, tr);
        V(g[3]) <+ transition(0.0, 0, tr, tr);
        V(g[2]) <+ transition(0.0, 0, tr, tr);
        V(g[1]) <+ transition(0.0, 0, tr, tr);
        V(g[0]) <+ transition(0.0, 0, tr, tr);
    end
endmodule
