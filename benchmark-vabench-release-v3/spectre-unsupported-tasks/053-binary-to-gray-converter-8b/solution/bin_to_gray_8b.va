`include "constants.vams"
`include "disciplines.vams"

module bin_to_gray_8b(
    input electrical [7:0] b,
    output electrical [7:0] g
);
    parameter real vdd = 0.9;
    parameter real vth = 0.45;
    parameter real tr = 20p;

    integer b7_q, b6_q, b5_q, b4_q, b3_q, b2_q, b1_q, b0_q;
    integer g7_q, g6_q, g5_q, g4_q, g3_q, g2_q, g1_q, g0_q;

    analog begin
        b7_q = (V(b[7]) > vth) ? 1 : 0;
        b6_q = (V(b[6]) > vth) ? 1 : 0;
        b5_q = (V(b[5]) > vth) ? 1 : 0;
        b4_q = (V(b[4]) > vth) ? 1 : 0;
        b3_q = (V(b[3]) > vth) ? 1 : 0;
        b2_q = (V(b[2]) > vth) ? 1 : 0;
        b1_q = (V(b[1]) > vth) ? 1 : 0;
        b0_q = (V(b[0]) > vth) ? 1 : 0;

        g7_q = b7_q;
        g6_q = (b7_q != b6_q) ? 1 : 0;
        g5_q = (b6_q != b5_q) ? 1 : 0;
        g4_q = (b5_q != b4_q) ? 1 : 0;
        g3_q = (b4_q != b3_q) ? 1 : 0;
        g2_q = (b3_q != b2_q) ? 1 : 0;
        g1_q = (b2_q != b1_q) ? 1 : 0;
        g0_q = (b1_q != b0_q) ? 1 : 0;

        V(g[7]) <+ transition(g7_q ? vdd : 0.0, 0, tr, tr);
        V(g[6]) <+ transition(g6_q ? vdd : 0.0, 0, tr, tr);
        V(g[5]) <+ transition(g5_q ? vdd : 0.0, 0, tr, tr);
        V(g[4]) <+ transition(g4_q ? vdd : 0.0, 0, tr, tr);
        V(g[3]) <+ transition(g3_q ? vdd : 0.0, 0, tr, tr);
        V(g[2]) <+ transition(g2_q ? vdd : 0.0, 0, tr, tr);
        V(g[1]) <+ transition(g1_q ? vdd : 0.0, 0, tr, tr);
        V(g[0]) <+ transition(g0_q ? vdd : 0.0, 0, tr, tr);
    end
endmodule
