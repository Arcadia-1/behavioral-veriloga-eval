module always_resettable_toggle(clk, rst, d, en, q);
    input clk, rst, d, en;
    output q;
    logic clk, rst, d, en, q;

    always @(posedge clk or posedge rst) begin q = ~q; end
endmodule
