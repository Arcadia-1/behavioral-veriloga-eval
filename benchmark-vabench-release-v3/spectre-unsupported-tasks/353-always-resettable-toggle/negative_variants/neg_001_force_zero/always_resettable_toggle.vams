module always_resettable_toggle(clk, rst, d, en, q);
    input clk, rst, d, en;
    output q;
    logic clk, rst, d, en, q;

    always @(posedge clk or posedge rst) begin if (rst) q = 1'b0; else if (en & d) q = 1'b0; end
endmodule
