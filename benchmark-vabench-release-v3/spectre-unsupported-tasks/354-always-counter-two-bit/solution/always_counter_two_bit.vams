module always_counter_two_bit(clk, rst, d, en, q);
    input clk, rst, d, en;
    output q;
    logic clk, rst, d, en, q;
    logic [1:0] count;

    always @(posedge clk) begin
        if (rst) count = 2'b00;
        else if (en & d) count = count + 1;
        else count = count;
    end

    assign q = count[1];
endmodule
