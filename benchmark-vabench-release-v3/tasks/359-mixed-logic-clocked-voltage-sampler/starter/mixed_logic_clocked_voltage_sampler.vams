`include "constants.vams"
`include "disciplines.vams"

module mixed_logic_clocked_voltage_sampler(vin, clk, en, sel, a, b, vout);
    input vin, clk, en, sel, a, b;
    output vout;
    electrical vin, vout;
    logic clk, en, sel;
    wreal a, b, level;
    logic sampled;
    parameter real tr = 200p;
    // TODO: implement the requested clocked mixed-signal sampler.
endmodule
