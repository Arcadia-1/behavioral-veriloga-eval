`include "constants.vams"
`include "disciplines.vams"

module low_active_enable_decoder_4b(en_n, a0, a1, a2, a3, y0_n, y1_n, y2_n, y3_n, y4_n, y5_n, y6_n, y7_n, y8_n, y9_n, y10_n, y11_n, y12_n, y13_n, y14_n, y15_n);
    input en_n, a0, a1, a2, a3;
    output y0_n, y1_n, y2_n, y3_n, y4_n, y5_n, y6_n, y7_n, y8_n, y9_n, y10_n, y11_n, y12_n, y13_n, y14_n, y15_n;
    electrical en_n, a0, a1, a2, a3, y0_n, y1_n, y2_n, y3_n, y4_n, y5_n, y6_n, y7_n, y8_n, y9_n, y10_n, y11_n, y12_n, y13_n, y14_n, y15_n;

    parameter real vdd = 0.9;
    parameter real vth = 0.45;
    parameter real tr = 20p;

    analog begin
        V(y0_n) <+ transition(0.0, 0, tr, tr);
        V(y1_n) <+ transition(0.0, 0, tr, tr);
        V(y2_n) <+ transition(0.0, 0, tr, tr);
        V(y3_n) <+ transition(0.0, 0, tr, tr);
        V(y4_n) <+ transition(0.0, 0, tr, tr);
        V(y5_n) <+ transition(0.0, 0, tr, tr);
        V(y6_n) <+ transition(0.0, 0, tr, tr);
        V(y7_n) <+ transition(0.0, 0, tr, tr);
        V(y8_n) <+ transition(0.0, 0, tr, tr);
        V(y9_n) <+ transition(0.0, 0, tr, tr);
        V(y10_n) <+ transition(0.0, 0, tr, tr);
        V(y11_n) <+ transition(0.0, 0, tr, tr);
        V(y12_n) <+ transition(0.0, 0, tr, tr);
        V(y13_n) <+ transition(0.0, 0, tr, tr);
        V(y14_n) <+ transition(0.0, 0, tr, tr);
        V(y15_n) <+ transition(0.0, 0, tr, tr);
    end
endmodule
