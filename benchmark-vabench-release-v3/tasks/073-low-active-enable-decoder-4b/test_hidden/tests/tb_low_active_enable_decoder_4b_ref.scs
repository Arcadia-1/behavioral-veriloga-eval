simulator lang=spectre
global 0
ahdl_include "low_active_enable_decoder_4b.va"
Ven_n (en_n 0) vsource type=pwl wave=[0 0 160n 0 160.1n 0.9 180n 0.9]
Va0 (a0 0) vsource type=pwl wave=[0 0 9.5n 0 10n 0.9 19.5n 0.9 20n 0 29.5n 0 30n 0.9 39.5n 0.9 40n 0 49.5n 0 50n 0.9 59.5n 0.9 60n 0 69.5n 0 70n 0.9 79.5n 0.9 80n 0 89.5n 0 90n 0.9 99.5n 0.9 100n 0 109.5n 0 110n 0.9 119.5n 0.9 120n 0 129.5n 0 130n 0.9 139.5n 0.9 140n 0 149.5n 0 150n 0.9 159.5n 0.9 160n 0.9]
Va1 (a1 0) vsource type=pwl wave=[0 0 9.5n 0 10n 0 19.5n 0 20n 0.9 29.5n 0.9 30n 0.9 39.5n 0.9 40n 0 49.5n 0 50n 0 59.5n 0 60n 0.9 69.5n 0.9 70n 0.9 79.5n 0.9 80n 0 89.5n 0 90n 0 99.5n 0 100n 0.9 109.5n 0.9 110n 0.9 119.5n 0.9 120n 0 129.5n 0 130n 0 139.5n 0 140n 0.9 149.5n 0.9 150n 0.9 159.5n 0.9 160n 0.9]
Va2 (a2 0) vsource type=pwl wave=[0 0 9.5n 0 10n 0 19.5n 0 20n 0 29.5n 0 30n 0 39.5n 0 40n 0.9 49.5n 0.9 50n 0.9 59.5n 0.9 60n 0.9 69.5n 0.9 70n 0.9 79.5n 0.9 80n 0 89.5n 0 90n 0 99.5n 0 100n 0 109.5n 0 110n 0 119.5n 0 120n 0.9 129.5n 0.9 130n 0.9 139.5n 0.9 140n 0.9 149.5n 0.9 150n 0.9 159.5n 0.9 160n 0.9]
Va3 (a3 0) vsource type=pwl wave=[0 0 9.5n 0 10n 0 19.5n 0 20n 0 29.5n 0 30n 0 39.5n 0 40n 0 49.5n 0 50n 0 59.5n 0 60n 0 69.5n 0 70n 0 79.5n 0 80n 0.9 89.5n 0.9 90n 0.9 99.5n 0.9 100n 0.9 109.5n 0.9 110n 0.9 119.5n 0.9 120n 0.9 129.5n 0.9 130n 0.9 139.5n 0.9 140n 0.9 149.5n 0.9 150n 0.9 159.5n 0.9 160n 0.9]
XDUT (en_n a0 a1 a2 a3 y0_n y1_n y2_n y3_n y4_n y5_n y6_n y7_n y8_n y9_n y10_n y11_n y12_n y13_n y14_n y15_n) low_active_enable_decoder_4b
tran tran stop=180n maxstep=100p
save en_n a0 a1 a2 a3 y0_n y1_n y2_n y3_n y4_n y5_n y6_n y7_n y8_n y9_n y10_n y11_n y12_n y13_n y14_n y15_n
