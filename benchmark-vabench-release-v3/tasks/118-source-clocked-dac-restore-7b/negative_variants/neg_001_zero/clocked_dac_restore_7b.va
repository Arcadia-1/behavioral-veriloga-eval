`include "constants.vams"
`include "disciplines.vams"

module clocked_dac_restore_7b(D1, D2, D3, D4, D5, D6, D0, CLK, VOUT);
    input D1, D2, D3, D4, D5, D6, D0, CLK;
    output VOUT;
    electrical D1, D2, D3, D4, D5, D6, D0, CLK, VOUT;
    parameter real vth = 0.45;
    parameter real lsb = 1.8 / 128.0;
    parameter real tr = 20p;

    // TODO: implement clocked 7-bit mid-rise DAC reconstruction.
endmodule
