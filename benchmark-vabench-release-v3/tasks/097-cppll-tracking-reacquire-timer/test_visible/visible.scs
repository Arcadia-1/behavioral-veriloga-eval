// Gold smoke testbench for CPPLL relock after a reference-frequency step.
simulator lang=spectre
global 0

ahdl_include "cppll_timer_ref.va"
ahdl_include "ref_step_clk.va"

VDD_SRC (VDD 0) vsource type=dc dc=0.9
VSS_SRC (VSS 0) vsource type=dc dc=0

XREF (VDD VSS ref_clk) ref_step_clk \
    period_pre=20.4n period_post=19.8n t_switch=2u tedge=100p

XDUT (VDD VSS ref_clk fb_clk dco_clk vctrl_mon lock) cppll_timer_ref \
    div_ratio=8 f_center=784.313725e6 kvco_hz_per_v=220e6 f_min=500e6 f_max=1.2e9 \
    kp=2.5e6 ki=8.0e4 vctrl_init=0.45 tedge=1n lock_tol=1.2n lock_count_target=4

tran tran stop=6u maxstep=5n errpreset=conservative
save ref_clk fb_clk dco_clk vctrl_mon lock
