`include "constants.vams"
`include "disciplines.vams"
module cppll_timer_ref(VDD, VSS, ref_clk, fb_clk, dco_clk, vctrl_mon, lock);
    inout electrical VDD, VSS;
    input electrical ref_clk;
    output electrical fb_clk, dco_clk, vctrl_mon, lock;
    parameter integer div_ratio = 8;
    parameter real kvco_hz_per_v = 175.0e6;  // half of correct
    parameter real f_center = 800.0e6, f_min = 300.0e6, f_max = 1.6e9;
    parameter real kp = 8.0e6, ki = 1.2e5;
    parameter real integ_min = -0.45, integ_max = 0.45, vctrl_init = 0.45;
    parameter real tedge = 20p, lock_tol = 0.4e-9;
    parameter integer lock_count_target = 6;
    real vh, vl, vcm, vth, ref_period, phase_err, integ, vctrl, dco_freq, dco_half_period, t_next_toggle;
    integer dco_state, fb_state, div_cnt, lock_state, lock_streak;
    analog begin
        vh = V(VDD); vl = V(VSS); vcm = 0.5*(vh+vl); vth = vcm;
        @(initial_step) begin
            vctrl = vctrl_init; dco_freq = f_center + kvco_hz_per_v*(vctrl-vcm);
            if(dco_freq<f_min) dco_freq=f_min; if(dco_freq>f_max) dco_freq=f_max;
            dco_half_period = 0.5/dco_freq; t_next_toggle = $abstime + dco_half_period;
        end
        @(cross(V(ref_clk)-vth, +1)) begin
            phase_err = 0; integ = integ + ki*phase_err;
            if(integ<integ_min) integ=integ_min; if(integ>integ_max) integ=integ_max;
            vctrl = vcm + kp*phase_err + integ;
            if(vctrl<vl) vctrl=vl; if(vctrl>vh) vctrl=vh;
        end
        @(timer(t_next_toggle)) begin
            dco_state = 1-dco_state;
            if(dco_state==1) begin div_cnt=div_cnt+1; if(div_cnt>=div_ratio) begin div_cnt=0; fb_state=1-fb_state; end end
            dco_freq = f_center + kvco_hz_per_v*(vctrl-vcm);
            if(dco_freq<f_min) dco_freq=f_min; if(dco_freq>f_max) dco_freq=f_max;
            $bound_step(1.0/(64.0*dco_freq));
            dco_half_period = 0.5/dco_freq; t_next_toggle = t_next_toggle + dco_half_period;
        end
        V(dco_clk) <+ vl + (vh-vl)*transition(dco_state,0,tedge,tedge);
        V(fb_clk) <+ vl + (vh-vl)*transition(fb_state,0,tedge,tedge);
        V(vctrl_mon) <+ vctrl;
        V(lock) <+ vl + (vh-vl)*transition(lock_state,0,tedge,tedge);
    end
endmodule
