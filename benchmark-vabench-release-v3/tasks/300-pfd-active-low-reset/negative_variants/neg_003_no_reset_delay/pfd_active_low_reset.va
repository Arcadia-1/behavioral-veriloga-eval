`include "disciplines.vams"
module pfd_active_low_reset(ref, fb, upb, down);
input ref, fb;
output upb, down;
electrical ref, fb, upb, down;
parameter real vth = 0.45;
parameter real vh = 0.9;
parameter real reset_delay = 80p;
integer up_state, down_state;
real trst;
analog begin
    @(initial_step) begin
        up_state = 0;
        down_state = 0;
        trst = -1.0;
    end
    @(cross(V(ref) - vth, +1)) begin
        up_state = 1;
        if (down_state == 1) trst = $abstime + 1p;
    end
    @(cross(V(fb) - vth, +1)) begin
        down_state = 1;
        if (up_state == 1) trst = $abstime + 1p;
    end
    @(timer(trst)) begin
        up_state = 0;
        down_state = 0;
        trst = -1.0;
    end
    V(upb) <+ transition(up_state ? 0.0 : vh, 0, 10p);
    V(down) <+ transition(down_state ? vh : 0.0, 0, 10p);
end
endmodule
