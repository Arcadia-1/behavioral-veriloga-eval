`include "disciplines.vams"
module pfd_active_low_reset(ref, fb, upb, down);
input ref, fb;
output upb, down;
electrical ref, fb, upb, down;
analog begin
    V(upb) <+ 0.0;
    V(down) <+ 0.0;
end
endmodule
