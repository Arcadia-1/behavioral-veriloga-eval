`include "constants.vams"
`include "disciplines.vams"
module acquisition_limited_sample_hold(sample, rst, vin, vout, metric);
    input electrical sample;
    input electrical rst;
    input electrical vin;
    output electrical vout;
    output electrical metric;
    analog begin
        V(vout) <+ V(vin);
        V(metric) <+ V(vin);
    end
endmodule
