`include "constants.vams"
`include "disciplines.vams"
module acquisition_limited_sample_hold (VDD, VSS, vin, vout);
    inout electrical VDD, VSS;
    input electrical vin;
    output electrical vout;
    analog begin
        V(vout) <+ V(VDD)/2;
    end
endmodule
