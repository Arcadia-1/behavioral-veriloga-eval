`include "constants.vams"
`include "disciplines.vams"
module acquisition_limited_sample_hold(sample, rst, vin, vout, metric);
    input electrical sample;
    input electrical rst;
    input electrical vin;
    output electrical vout;
    output electrical metric;
    analog begin
        V(vout) <+ 0;
        V(metric) <+ 0;
    end
endmodule
