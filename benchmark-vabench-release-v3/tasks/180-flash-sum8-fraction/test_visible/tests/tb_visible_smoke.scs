simulator lang=spectre
global 0

ahdl_include "flash_sum8_fraction.va"

Vd0 (din0 0) vsource type=pwl wave=[0 0 9.9n 0 10.1n 0.9 19.9n 0.9 20.1n 0.9 29.9n 0.9 30.1n 0.9 38n 0.9]
Vd1 (din1 0) vsource type=pwl wave=[0 0 9.9n 0 10.1n 0.9 19.9n 0.9 20.1n 0.9 29.9n 0.9 30.1n 0.9 38n 0.9]
Vd2 (din2 0) vsource type=pwl wave=[0 0 9.9n 0 10.1n 0.9 19.9n 0.9 20.1n 0.9 29.9n 0.9 30.1n 0.9 38n 0.9]
Vd3 (din3 0) vsource type=pwl wave=[0 0 9.9n 0 10.1n 0 19.9n 0 20.1n 0.9 29.9n 0.9 30.1n 0.9 38n 0.9]
Vd4 (din4 0) vsource type=pwl wave=[0 0 9.9n 0 10.1n 0 19.9n 0 20.1n 0.9 29.9n 0.9 30.1n 0.9 38n 0.9]
Vd5 (din5 0) vsource type=pwl wave=[0 0 9.9n 0 10.1n 0 19.9n 0 20.1n 0 29.9n 0 30.1n 0.9 38n 0.9]
Vd6 (din6 0) vsource type=pwl wave=[0 0 9.9n 0 10.1n 0 19.9n 0 20.1n 0 29.9n 0 30.1n 0.9 38n 0.9]
Vd7 (din7 0) vsource type=pwl wave=[0 0 9.9n 0 10.1n 0 19.9n 0 20.1n 0 29.9n 0 30.1n 0.9 38n 0.9]
Vclk (clks 0) vsource type=pwl wave=[0 0 2n 0 2.1n 0.9 2.5n 0.9 2.6n 0 12n 0 12.1n 0.9 12.5n 0.9 12.6n 0 22n 0 22.1n 0.9 22.5n 0.9 22.6n 0 32n 0 32.1n 0.9 32.5n 0.9 32.6n 0 38n 0]

XDUT (din0 din1 din2 din3 din4 din5 din6 din7 clks dout) flash_sum8_fraction

tran tran stop=25n maxstep=20p
save din0 din1 din2 din3 din4 din5 din6 din7 clks dout
