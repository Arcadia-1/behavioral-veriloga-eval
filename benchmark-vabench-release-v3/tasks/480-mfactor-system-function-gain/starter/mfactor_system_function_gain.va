`include "constants.vams"
`include "disciplines.vams"

module mfactor_system_function_gain (
    input  electrical in,
    output electrical out
);
real m_eff;
analog begin
    m_eff = $mfactor();
    V(out) <+ transition(0.0, 0.0, 200p, 200p);
end
endmodule
