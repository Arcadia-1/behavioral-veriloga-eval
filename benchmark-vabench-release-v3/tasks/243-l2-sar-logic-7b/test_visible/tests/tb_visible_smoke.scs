simulator lang=spectre
global 0
ahdl_include "l2_sar_logic_7b.va"
Vclks (clks 0) vsource type=pulse val0=0 val1=1.1 delay=0.05n period=20n width=0.25n rise=20p fall=20p
Vclkc (clkc 0) vsource type=pulse val0=0 val1=1.1 delay=0.8n period=20n width=0.25n rise=20p fall=20p
Vp (dcmpp 0) vsource type=pwl wave=[0 0 1.25n 0 1.27n 1.1 1.55n 1.1 1.57n 0 2.65n 0 2.67n 1.1 2.95n 1.1 2.97n 0 3.35n 0 3.37n 1.1 3.65n 1.1 3.67n 0 5.45n 0 5.47n 1.1 5.75n 1.1 5.77n 0 6.3n 0]
Vn (dcmpn 0) vsource type=pwl wave=[0 0 1.95n 0 1.97n 1.1 2.25n 1.1 2.27n 0 4.05n 0 4.07n 1.1 4.35n 1.1 4.37n 0 4.75n 0 4.77n 1.1 5.05n 1.1 5.07n 0 6.3n 0]
XDUT (clkc clks dcmpp dcmpn cmpck do0 do1 do2 do3 do4 do5 do6 dctrlp1 dctrlp2 dctrlp3 dctrlp4 dctrlp5 dctrlp6 dctrln1 dctrln2 dctrln3 dctrln4 dctrln5 dctrln6) l2_sar_logic_7b
tran tran stop=6.05n maxstep=10p
save clkc clks dcmpp dcmpn cmpck do0 do1 do2 do3 do4 do5 do6 dctrlp1 dctrlp2 dctrlp3 dctrlp4 dctrlp5 dctrlp6 dctrln1 dctrln2 dctrln3 dctrln4 dctrln5 dctrln6
