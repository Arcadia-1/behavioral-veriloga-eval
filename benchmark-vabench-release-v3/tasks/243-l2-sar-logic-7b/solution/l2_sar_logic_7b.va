`include "disciplines.vams"
module l2_sar_logic_7b(clkc, clks, dcmpp, dcmpn, cmpck, do0, do1, do2, do3, do4, do5, do6, dctrlp1, dctrlp2, dctrlp3, dctrlp4, dctrlp5, dctrlp6, dctrln1, dctrln2, dctrln3, dctrln4, dctrln5, dctrln6);
input clkc, clks, dcmpp, dcmpn;
output cmpck, do0, do1, do2, do3, do4, do5, do6, dctrlp1, dctrlp2, dctrlp3, dctrlp4, dctrlp5, dctrlp6, dctrln1, dctrln2, dctrln3, dctrln4, dctrln5, dctrln6;
electrical clkc, clks, dcmpp, dcmpn, cmpck, do0, do1, do2, do3, do4, do5, do6, dctrlp1, dctrlp2, dctrlp3, dctrlp4, dctrlp5, dctrlp6, dctrln1, dctrln2, dctrln3, dctrln4, dctrln5, dctrln6;
parameter real vdd = 1.1;
parameter real t_logic_delay = 100p;
integer step, cmpck_i;
integer dout0, dout1, dout2, dout3, dout4, dout5, dout6;
integer dp1, dp2, dp3, dp4, dp5, dp6, dn1, dn2, dn3, dn4, dn5, dn6;
analog begin
    @(initial_step or cross(V(clks) - vdd / 2.0, +1)) begin
        step = 6;
        cmpck_i = 0;
        dout0 = 0; dout1 = 0; dout2 = 0; dout3 = 0; dout4 = 0; dout5 = 0; dout6 = 0;
        dp1 = 0; dp2 = 0; dp3 = 0; dp4 = 0; dp5 = 0; dp6 = 0;
        dn1 = 0; dn2 = 0; dn3 = 0; dn4 = 0; dn5 = 0; dn6 = 0;
    end
    @(cross(V(clkc) - vdd / 2.0, +1)) cmpck_i = 1;
    @(cross(V(dcmpp) - vdd / 2.0, +1) or cross(V(dcmpn) - vdd / 2.0, +1)) begin
        cmpck_i = 0;
        if (step == 6) dout6 = V(dcmpp) > V(dcmpn);
        else if (step == 5) dout5 = V(dcmpp) > V(dcmpn);
        else if (step == 4) dout4 = V(dcmpp) > V(dcmpn);
        else if (step == 3) dout3 = V(dcmpp) > V(dcmpn);
        else if (step == 2) dout2 = V(dcmpp) > V(dcmpn);
        else if (step == 1) dout1 = V(dcmpp) > V(dcmpn);
        else if (step == 0) dout0 = V(dcmpp) > V(dcmpn);
        if (step >= 1) begin
            if (V(dcmpp) > V(dcmpn)) begin
                if (step == 6) dn6 = 1; else if (step == 5) dn5 = 1; else if (step == 4) dn4 = 1; else if (step == 3) dn3 = 1; else if (step == 2) dn2 = 1; else if (step == 1) dn1 = 1;
            end else begin
                if (step == 6) dp6 = 1; else if (step == 5) dp5 = 1; else if (step == 4) dp4 = 1; else if (step == 3) dp3 = 1; else if (step == 2) dp2 = 1; else if (step == 1) dp1 = 1;
            end
        end
    end
    @(cross(V(dcmpp) - vdd / 2.0, -1) or cross(V(dcmpn) - vdd / 2.0, -1)) begin
        step = step - 1;
        if (step >= 0) cmpck_i = 1;
    end
    V(cmpck) <+ transition(cmpck_i * vdd, t_logic_delay, 20p, 20p);
    V(do0) <+ transition(dout0 * vdd, 0, 20p, 20p); V(do1) <+ transition(dout1 * vdd, 0, 20p, 20p); V(do2) <+ transition(dout2 * vdd, 0, 20p, 20p); V(do3) <+ transition(dout3 * vdd, 0, 20p, 20p); V(do4) <+ transition(dout4 * vdd, 0, 20p, 20p); V(do5) <+ transition(dout5 * vdd, 0, 20p, 20p); V(do6) <+ transition(dout6 * vdd, 0, 20p, 20p);
    V(dctrlp1) <+ transition(dp1 * vdd, 0, 20p, 20p); V(dctrlp2) <+ transition(dp2 * vdd, 0, 20p, 20p); V(dctrlp3) <+ transition(dp3 * vdd, 0, 20p, 20p); V(dctrlp4) <+ transition(dp4 * vdd, 0, 20p, 20p); V(dctrlp5) <+ transition(dp5 * vdd, 0, 20p, 20p); V(dctrlp6) <+ transition(dp6 * vdd, 0, 20p, 20p);
    V(dctrln1) <+ transition(dn1 * vdd, 0, 20p, 20p); V(dctrln2) <+ transition(dn2 * vdd, 0, 20p, 20p); V(dctrln3) <+ transition(dn3 * vdd, 0, 20p, 20p); V(dctrln4) <+ transition(dn4 * vdd, 0, 20p, 20p); V(dctrln5) <+ transition(dn5 * vdd, 0, 20p, 20p); V(dctrln6) <+ transition(dn6 * vdd, 0, 20p, 20p);
end
endmodule
