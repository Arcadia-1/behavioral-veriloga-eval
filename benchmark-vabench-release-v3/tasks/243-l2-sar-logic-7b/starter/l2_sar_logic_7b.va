`include "disciplines.vams"
module l2_sar_logic_7b(clkc, clks, dcmpp, dcmpn, cmpck, do0, do1, do2, do3, do4, do5, do6, dctrlp1, dctrlp2, dctrlp3, dctrlp4, dctrlp5, dctrlp6, dctrln1, dctrln2, dctrln3, dctrln4, dctrln5, dctrln6);
input clkc, clks, dcmpp, dcmpn;
output cmpck, do0, do1, do2, do3, do4, do5, do6, dctrlp1, dctrlp2, dctrlp3, dctrlp4, dctrlp5, dctrlp6, dctrln1, dctrln2, dctrln3, dctrln4, dctrln5, dctrln6;
electrical clkc, clks, dcmpp, dcmpn, cmpck, do0, do1, do2, do3, do4, do5, do6, dctrlp1, dctrlp2, dctrlp3, dctrlp4, dctrlp5, dctrlp6, dctrln1, dctrln2, dctrln3, dctrln4, dctrln5, dctrln6;
analog begin
    V(cmpck) <+ 0.0; V(do0) <+ 0.0; V(do1) <+ 0.0; V(do2) <+ 0.0; V(do3) <+ 0.0; V(do4) <+ 0.0; V(do5) <+ 0.0; V(do6) <+ 0.0;
    V(dctrlp1) <+ 0.0; V(dctrlp2) <+ 0.0; V(dctrlp3) <+ 0.0; V(dctrlp4) <+ 0.0; V(dctrlp5) <+ 0.0; V(dctrlp6) <+ 0.0;
    V(dctrln1) <+ 0.0; V(dctrln2) <+ 0.0; V(dctrln3) <+ 0.0; V(dctrln4) <+ 0.0; V(dctrln5) <+ 0.0; V(dctrln6) <+ 0.0;
end
endmodule
