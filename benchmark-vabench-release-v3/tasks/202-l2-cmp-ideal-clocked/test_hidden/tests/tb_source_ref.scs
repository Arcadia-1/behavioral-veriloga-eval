simulator lang=spectre
global 0

ahdl_include "l2_cmp_ideal_clocked.va"

Vcmpck (cmpck 0) vsource type=pwl wave=[0 0 1n 0 1.05n 0.9 1.50n 0.9 1.55n 0 11n 0 11.05n 0.9 11.50n 0.9 11.55n 0 21n 0 21.05n 0.9 21.50n 0.9 21.55n 0 31n 0 31.05n 0.9 31.50n 0.9 31.55n 0]
Vvinp (vinp 0) vsource type=pwl wave=[0 0.6 7.95n 0.6 8n 0.2 17.95n 0.2 18n 0.4 27.95n 0.4 28n 0.7]
Vvinn (vinn 0) vsource type=pwl wave=[0 0.3 7.95n 0.3 8n 0.5 17.95n 0.5 18n 0.4 27.95n 0.4 28n 0.1]

XDUT (cmpck vinn vinp dcmpn dcmpp) l2_cmp_ideal_clocked

tran tran stop=40n maxstep=20p
save cmpck vinp vinn dcmpn dcmpp
