simulator lang=spectre
global 0
ahdl_include "dff_set_reset.va"
Vdd (vdd 0) vsource dc=0.9
Vgnd (gnd 0) vsource dc=0
Vclk (clk 0) vsource type=pulse val0=0 val1=0.9 delay=0.30n period=0.80n width=0.22n rise=20p fall=20p
Vd (d 0) vsource type=pwl wave=[0 0.9 0.95n 0.9 1.00n 0 1.75n 0 1.80n 0.9 3.8n 0.9]
Vrstb (rstb 0) vsource type=pwl wave=[0 0.9 1.85n 0.9 1.87n 0 2.18n 0 2.20n 0.9 3.8n 0.9]
Vsetb (setb 0) vsource type=pwl wave=[0 0.9 2.70n 0.9 2.72n 0 3.02n 0 3.04n 0.9 3.8n 0.9]
XDUT (setb rstb clk vdd gnd d q qb) dff_set_reset
tran tran stop=3.6n maxstep=5p
save setb rstb clk vdd gnd d q qb
