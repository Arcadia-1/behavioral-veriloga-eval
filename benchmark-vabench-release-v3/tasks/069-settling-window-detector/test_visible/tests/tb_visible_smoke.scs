simulator lang=spectre
global 0

ahdl_include "settling_window_detector.va"

V_vin (vin 0) vsource dc=0.55
V_target (target 0) vsource dc=0.6
V_tol (tol 0) vsource dc=0.08

XDUT (vin target tol settled t_code0 t_code1 t_code2 t_code3 t_code4 t_code5 t_code6 t_code7) settling_window_detector

tran tran stop=8n maxstep=100p
save vin target tol settled t_code0 t_code1 t_code2 t_code3 t_code4 t_code5 t_code6 t_code7
