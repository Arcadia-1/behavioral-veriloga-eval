simulator lang=spectre
global 0
// Hidden AC/noise-capable behavior skeleton.
tran tran stop=200n
