simulator lang=spectre
global 0

ahdl_include "half_subtractor_logic.va"

Vin1 (vin1 0) vsource type=pwl wave=[0 0 10n 0 10.1n 0 20n 0 20.1n 0.9 30n 0.9 30.1n 0.9 45n 0.9]
Vin2 (vin2 0) vsource type=pwl wave=[0 0 10n 0 10.1n 0.9 20n 0.9 20.1n 0 30n 0 30.1n 0.9 45n 0.9]

XDUT (vin1 vin2 vout_diff vout_borrow) half_subtractor_logic

tran tran stop=40n maxstep=25p
save vin1 vin2 vout_diff vout_borrow
