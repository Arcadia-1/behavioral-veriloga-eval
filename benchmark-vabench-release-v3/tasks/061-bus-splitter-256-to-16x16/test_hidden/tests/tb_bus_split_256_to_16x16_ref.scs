simulator lang=spectre
global 0

ahdl_include "bus_split_256_to_16x16.va"

Vin255 (in255 0) vsource type=pwl wave=[ 0n 0.9 9n 0.9 10n 0.9 19n 0.9 20n 0 29n 0 30n 0.9 39n 0.9 40n 0.9 49n 0.9 50n 0.9 59n 0.9 ]
Vin254 (in254 0) vsource type=pwl wave=[ 0n 0 9n 0 10n 0.9 19n 0.9 20n 0 29n 0 30n 0 39n 0 40n 0 49n 0 50n 0 59n 0 ]
Vin253 (in253 0) vsource type=pwl wave=[ 0n 0 9n 0 10n 0 19n 0 20n 0.9 29n 0.9 30n 0 39n 0 40n 0 49n 0 50n 0 59n 0 ]
Vin252 (in252 0) vsource type=pwl wave=[ 0n 0 9n 0 10n 0 19n 0 20n 0 29n 0 30n 0.9 39n 0.9 40n 0 49n 0 50n 0 59n 0 ]
Vin251 (in251 0) vsource type=pwl wave=[ 0n 0 9n 0 10n 0 19n 0 20n 0 29n 0 30n 0 39n 0 40n 0 49n 0 50n 0 59n 0 ]
Vin250 (in250 0) vsource type=pwl wave=[ 0n 0.9 9n 0.9 10n 0 19n 0 20n 0 29n 0 30n 0 39n 0 40n 0.9 49n 0.9 50n 0.9 59n 0.9 ]
Vin249 (in249 0) vsource type=pwl wave=[ 0n 0 9n 0 10n 0.9 19n 0.9 20n 0 29n 0 30n 0 39n 0 40n 0 49n 0 50n 0 59n 0 ]
Vin248 (in248 0) vsource type=pwl wave=[ 0n 0 9n 0 10n 0 19n 0 20n 0.9 29n 0.9 30n 0 39n 0 40n 0 49n 0 50n 0 59n 0 ]
Vin247 (in247 0) vsource type=pwl wave=[ 0n 0 9n 0 10n 0 19n 0 20n 0 29n 0 30n 0.9 39n 0.9 40n 0 49n 0 50n 0 59n 0 ]
Vin246 (in246 0) vsource type=pwl wave=[ 0n 0 9n 0 10n 0 19n 0 20n 0 29n 0 30n 0 39n 0 40n 0 49n 0 50n 0 59n 0 ]
Vin245 (in245 0) vsource type=pwl wave=[ 0n 0.9 9n 0.9 10n 0 19n 0 20n 0 29n 0 30n 0 39n 0 40n 0.9 49n 0.9 50n 0.9 59n 0.9 ]
Vin244 (in244 0) vsource type=pwl wave=[ 0n 0 9n 0 10n 0.9 19n 0.9 20n 0 29n 0 30n 0 39n 0 40n 0 49n 0 50n 0 59n 0 ]
Vin243 (in243 0) vsource type=pwl wave=[ 0n 0 9n 0 10n 0 19n 0 20n 0.9 29n 0.9 30n 0 39n 0 40n 0 49n 0 50n 0 59n 0 ]
Vin242 (in242 0) vsource type=pwl wave=[ 0n 0 9n 0 10n 0 19n 0 20n 0 29n 0 30n 0.9 39n 0.9 40n 0 49n 0 50n 0 59n 0 ]
Vin241 (in241 0) vsource type=pwl wave=[ 0n 0 9n 0 10n 0 19n 0 20n 0 29n 0 30n 0 39n 0 40n 0 49n 0 50n 0 59n 0 ]
Vin240 (in240 0) vsource type=pwl wave=[ 0n 0.9 9n 0.9 10n 0 19n 0 20n 0 29n 0 30n 0 39n 0 40n 0.9 49n 0.9 50n 0.9 59n 0.9 ]
Vin239 (in239 0) vsource type=pwl wave=[ 0n 0 9n 0 10n 0.9 19n 0.9 20n 0 29n 0 30n 0 39n 0 40n 0 49n 0 50n 0 59n 0 ]
Vin238 (in238 0) vsource type=pwl wave=[ 0n 0 9n 0 10n 0 19n 0 20n 0.9 29n 0.9 30n 0 39n 0 40n 0 49n 0 50n 0 59n 0 ]
Vin237 (in237 0) vsource type=pwl wave=[ 0n 0 9n 0 10n 0 19n 0 20n 0 29n 0 30n 0.9 39n 0.9 40n 0 49n 0 50n 0 59n 0 ]
Vin236 (in236 0) vsource type=pwl wave=[ 0n 0 9n 0 10n 0 19n 0 20n 0 29n 0 30n 0 39n 0 40n 0 49n 0 50n 0 59n 0 ]
Vin235 (in235 0) vsource type=pwl wave=[ 0n 0.9 9n 0.9 10n 0 19n 0 20n 0 29n 0 30n 0 39n 0 40n 0.9 49n 0.9 50n 0.9 59n 0.9 ]
Vin234 (in234 0) vsource type=pwl wave=[ 0n 0 9n 0 10n 0.9 19n 0.9 20n 0 29n 0 30n 0 39n 0 40n 0 49n 0 50n 0 59n 0 ]
Vin233 (in233 0) vsource type=pwl wave=[ 0n 0 9n 0 10n 0 19n 0 20n 0.9 29n 0.9 30n 0 39n 0 40n 0 49n 0 50n 0 59n 0 ]
Vin232 (in232 0) vsource type=pwl wave=[ 0n 0 9n 0 10n 0 19n 0 20n 0 29n 0 30n 0.9 39n 0.9 40n 0 49n 0 50n 0 59n 0 ]
Vin231 (in231 0) vsource type=pwl wave=[ 0n 0 9n 0 10n 0 19n 0 20n 0 29n 0 30n 0 39n 0 40n 0 49n 0 50n 0 59n 0 ]
Vin230 (in230 0) vsource type=pwl wave=[ 0n 0.9 9n 0.9 10n 0 19n 0 20n 0 29n 0 30n 0 39n 0 40n 0.9 49n 0.9 50n 0.9 59n 0.9 ]
Vin229 (in229 0) vsource type=pwl wave=[ 0n 0 9n 0 10n 0.9 19n 0.9 20n 0 29n 0 30n 0 39n 0 40n 0 49n 0 50n 0 59n 0 ]
Vin228 (in228 0) vsource type=pwl wave=[ 0n 0 9n 0 10n 0 19n 0 20n 0.9 29n 0.9 30n 0 39n 0 40n 0 49n 0 50n 0 59n 0 ]
Vin227 (in227 0) vsource type=pwl wave=[ 0n 0 9n 0 10n 0 19n 0 20n 0 29n 0 30n 0.9 39n 0.9 40n 0 49n 0 50n 0 59n 0 ]
Vin226 (in226 0) vsource type=pwl wave=[ 0n 0 9n 0 10n 0 19n 0 20n 0 29n 0 30n 0 39n 0 40n 0 49n 0 50n 0 59n 0 ]
Vin225 (in225 0) vsource type=pwl wave=[ 0n 0.9 9n 0.9 10n 0 19n 0 20n 0 29n 0 30n 0 39n 0 40n 0.9 49n 0.9 50n 0.9 59n 0.9 ]
Vin224 (in224 0) vsource type=pwl wave=[ 0n 0 9n 0 10n 0.9 19n 0.9 20n 0 29n 0 30n 0 39n 0 40n 0 49n 0 50n 0 59n 0 ]
Vin223 (in223 0) vsource type=pwl wave=[ 0n 0 9n 0 10n 0 19n 0 20n 0.9 29n 0.9 30n 0 39n 0 40n 0 49n 0 50n 0 59n 0 ]
Vin222 (in222 0) vsource type=pwl wave=[ 0n 0 9n 0 10n 0 19n 0 20n 0 29n 0 30n 0.9 39n 0.9 40n 0 49n 0 50n 0 59n 0 ]
Vin221 (in221 0) vsource type=pwl wave=[ 0n 0 9n 0 10n 0 19n 0 20n 0 29n 0 30n 0 39n 0 40n 0 49n 0 50n 0 59n 0 ]
Vin220 (in220 0) vsource type=pwl wave=[ 0n 0.9 9n 0.9 10n 0 19n 0 20n 0 29n 0 30n 0 39n 0 40n 0.9 49n 0.9 50n 0.9 59n 0.9 ]
Vin219 (in219 0) vsource type=pwl wave=[ 0n 0 9n 0 10n 0.9 19n 0.9 20n 0 29n 0 30n 0 39n 0 40n 0 49n 0 50n 0 59n 0 ]
Vin218 (in218 0) vsource type=pwl wave=[ 0n 0 9n 0 10n 0 19n 0 20n 0.9 29n 0.9 30n 0 39n 0 40n 0 49n 0 50n 0 59n 0 ]
Vin217 (in217 0) vsource type=pwl wave=[ 0n 0 9n 0 10n 0 19n 0 20n 0 29n 0 30n 0.9 39n 0.9 40n 0 49n 0 50n 0 59n 0 ]
Vin216 (in216 0) vsource type=pwl wave=[ 0n 0 9n 0 10n 0 19n 0 20n 0 29n 0 30n 0 39n 0 40n 0 49n 0 50n 0 59n 0 ]
Vin215 (in215 0) vsource type=pwl wave=[ 0n 0.9 9n 0.9 10n 0 19n 0 20n 0 29n 0 30n 0 39n 0 40n 0.9 49n 0.9 50n 0.9 59n 0.9 ]
Vin214 (in214 0) vsource type=pwl wave=[ 0n 0 9n 0 10n 0.9 19n 0.9 20n 0 29n 0 30n 0 39n 0 40n 0 49n 0 50n 0 59n 0 ]
Vin213 (in213 0) vsource type=pwl wave=[ 0n 0 9n 0 10n 0 19n 0 20n 0.9 29n 0.9 30n 0 39n 0 40n 0 49n 0 50n 0 59n 0 ]
Vin212 (in212 0) vsource type=pwl wave=[ 0n 0 9n 0 10n 0 19n 0 20n 0 29n 0 30n 0.9 39n 0.9 40n 0 49n 0 50n 0 59n 0 ]
Vin211 (in211 0) vsource type=pwl wave=[ 0n 0 9n 0 10n 0 19n 0 20n 0 29n 0 30n 0 39n 0 40n 0 49n 0 50n 0 59n 0 ]
Vin210 (in210 0) vsource type=pwl wave=[ 0n 0.9 9n 0.9 10n 0 19n 0 20n 0 29n 0 30n 0 39n 0 40n 0.9 49n 0.9 50n 0.9 59n 0.9 ]
Vin209 (in209 0) vsource type=pwl wave=[ 0n 0 9n 0 10n 0.9 19n 0.9 20n 0 29n 0 30n 0 39n 0 40n 0 49n 0 50n 0 59n 0 ]
Vin208 (in208 0) vsource type=pwl wave=[ 0n 0 9n 0 10n 0 19n 0 20n 0.9 29n 0.9 30n 0 39n 0 40n 0 49n 0 50n 0 59n 0 ]
Vin207 (in207 0) vsource type=pwl wave=[ 0n 0 9n 0 10n 0 19n 0 20n 0 29n 0 30n 0.9 39n 0.9 40n 0 49n 0 50n 0 59n 0 ]
Vin206 (in206 0) vsource type=pwl wave=[ 0n 0 9n 0 10n 0 19n 0 20n 0 29n 0 30n 0 39n 0 40n 0 49n 0 50n 0 59n 0 ]
Vin205 (in205 0) vsource type=pwl wave=[ 0n 0.9 9n 0.9 10n 0 19n 0 20n 0 29n 0 30n 0 39n 0 40n 0.9 49n 0.9 50n 0.9 59n 0.9 ]
Vin204 (in204 0) vsource type=pwl wave=[ 0n 0 9n 0 10n 0.9 19n 0.9 20n 0 29n 0 30n 0 39n 0 40n 0 49n 0 50n 0 59n 0 ]
Vin203 (in203 0) vsource type=pwl wave=[ 0n 0 9n 0 10n 0 19n 0 20n 0.9 29n 0.9 30n 0 39n 0 40n 0 49n 0 50n 0 59n 0 ]
Vin202 (in202 0) vsource type=pwl wave=[ 0n 0 9n 0 10n 0 19n 0 20n 0 29n 0 30n 0.9 39n 0.9 40n 0 49n 0 50n 0 59n 0 ]
Vin201 (in201 0) vsource type=pwl wave=[ 0n 0 9n 0 10n 0 19n 0 20n 0 29n 0 30n 0 39n 0 40n 0 49n 0 50n 0 59n 0 ]
Vin200 (in200 0) vsource type=pwl wave=[ 0n 0.9 9n 0.9 10n 0 19n 0 20n 0 29n 0 30n 0 39n 0 40n 0.9 49n 0.9 50n 0.9 59n 0.9 ]
Vin199 (in199 0) vsource type=pwl wave=[ 0n 0 9n 0 10n 0.9 19n 0.9 20n 0 29n 0 30n 0 39n 0 40n 0 49n 0 50n 0 59n 0 ]
Vin198 (in198 0) vsource type=pwl wave=[ 0n 0 9n 0 10n 0 19n 0 20n 0.9 29n 0.9 30n 0 39n 0 40n 0 49n 0 50n 0 59n 0 ]
Vin197 (in197 0) vsource type=pwl wave=[ 0n 0 9n 0 10n 0 19n 0 20n 0 29n 0 30n 0.9 39n 0.9 40n 0 49n 0 50n 0 59n 0 ]
Vin196 (in196 0) vsource type=pwl wave=[ 0n 0 9n 0 10n 0 19n 0 20n 0 29n 0 30n 0 39n 0 40n 0 49n 0 50n 0 59n 0 ]
Vin195 (in195 0) vsource type=pwl wave=[ 0n 0.9 9n 0.9 10n 0 19n 0 20n 0 29n 0 30n 0 39n 0 40n 0.9 49n 0.9 50n 0.9 59n 0.9 ]
Vin194 (in194 0) vsource type=pwl wave=[ 0n 0 9n 0 10n 0.9 19n 0.9 20n 0 29n 0 30n 0 39n 0 40n 0 49n 0 50n 0 59n 0 ]
Vin193 (in193 0) vsource type=pwl wave=[ 0n 0 9n 0 10n 0 19n 0 20n 0.9 29n 0.9 30n 0 39n 0 40n 0 49n 0 50n 0 59n 0 ]
Vin192 (in192 0) vsource type=pwl wave=[ 0n 0 9n 0 10n 0 19n 0 20n 0 29n 0 30n 0.9 39n 0.9 40n 0 49n 0 50n 0 59n 0 ]
Vin191 (in191 0) vsource type=pwl wave=[ 0n 0 9n 0 10n 0 19n 0 20n 0 29n 0 30n 0 39n 0 40n 0 49n 0 50n 0 59n 0 ]
Vin190 (in190 0) vsource type=pwl wave=[ 0n 0.9 9n 0.9 10n 0 19n 0 20n 0 29n 0 30n 0 39n 0 40n 0.9 49n 0.9 50n 0.9 59n 0.9 ]
Vin189 (in189 0) vsource type=pwl wave=[ 0n 0 9n 0 10n 0.9 19n 0.9 20n 0 29n 0 30n 0 39n 0 40n 0 49n 0 50n 0 59n 0 ]
Vin188 (in188 0) vsource type=pwl wave=[ 0n 0 9n 0 10n 0 19n 0 20n 0.9 29n 0.9 30n 0 39n 0 40n 0 49n 0 50n 0 59n 0 ]
Vin187 (in187 0) vsource type=pwl wave=[ 0n 0 9n 0 10n 0 19n 0 20n 0 29n 0 30n 0.9 39n 0.9 40n 0 49n 0 50n 0 59n 0 ]
Vin186 (in186 0) vsource type=pwl wave=[ 0n 0 9n 0 10n 0 19n 0 20n 0 29n 0 30n 0 39n 0 40n 0 49n 0 50n 0 59n 0 ]
Vin185 (in185 0) vsource type=pwl wave=[ 0n 0.9 9n 0.9 10n 0 19n 0 20n 0 29n 0 30n 0 39n 0 40n 0.9 49n 0.9 50n 0.9 59n 0.9 ]
Vin184 (in184 0) vsource type=pwl wave=[ 0n 0 9n 0 10n 0.9 19n 0.9 20n 0 29n 0 30n 0 39n 0 40n 0 49n 0 50n 0 59n 0 ]
Vin183 (in183 0) vsource type=pwl wave=[ 0n 0 9n 0 10n 0 19n 0 20n 0.9 29n 0.9 30n 0 39n 0 40n 0 49n 0 50n 0 59n 0 ]
Vin182 (in182 0) vsource type=pwl wave=[ 0n 0 9n 0 10n 0 19n 0 20n 0 29n 0 30n 0.9 39n 0.9 40n 0 49n 0 50n 0 59n 0 ]
Vin181 (in181 0) vsource type=pwl wave=[ 0n 0 9n 0 10n 0 19n 0 20n 0 29n 0 30n 0 39n 0 40n 0 49n 0 50n 0 59n 0 ]
Vin180 (in180 0) vsource type=pwl wave=[ 0n 0.9 9n 0.9 10n 0 19n 0 20n 0 29n 0 30n 0 39n 0 40n 0.9 49n 0.9 50n 0.9 59n 0.9 ]
Vin179 (in179 0) vsource type=pwl wave=[ 0n 0 9n 0 10n 0.9 19n 0.9 20n 0 29n 0 30n 0 39n 0 40n 0 49n 0 50n 0 59n 0 ]
Vin178 (in178 0) vsource type=pwl wave=[ 0n 0 9n 0 10n 0 19n 0 20n 0.9 29n 0.9 30n 0 39n 0 40n 0 49n 0 50n 0 59n 0 ]
Vin177 (in177 0) vsource type=pwl wave=[ 0n 0 9n 0 10n 0 19n 0 20n 0 29n 0 30n 0.9 39n 0.9 40n 0 49n 0 50n 0 59n 0 ]
Vin176 (in176 0) vsource type=pwl wave=[ 0n 0 9n 0 10n 0 19n 0 20n 0 29n 0 30n 0 39n 0 40n 0 49n 0 50n 0 59n 0 ]
Vin175 (in175 0) vsource type=pwl wave=[ 0n 0.9 9n 0.9 10n 0 19n 0 20n 0 29n 0 30n 0 39n 0 40n 0.9 49n 0.9 50n 0.9 59n 0.9 ]
Vin174 (in174 0) vsource type=pwl wave=[ 0n 0 9n 0 10n 0.9 19n 0.9 20n 0 29n 0 30n 0 39n 0 40n 0 49n 0 50n 0 59n 0 ]
Vin173 (in173 0) vsource type=pwl wave=[ 0n 0 9n 0 10n 0 19n 0 20n 0.9 29n 0.9 30n 0 39n 0 40n 0 49n 0 50n 0 59n 0 ]
Vin172 (in172 0) vsource type=pwl wave=[ 0n 0 9n 0 10n 0 19n 0 20n 0 29n 0 30n 0.9 39n 0.9 40n 0 49n 0 50n 0 59n 0 ]
Vin171 (in171 0) vsource type=pwl wave=[ 0n 0 9n 0 10n 0 19n 0 20n 0 29n 0 30n 0 39n 0 40n 0 49n 0 50n 0 59n 0 ]
Vin170 (in170 0) vsource type=pwl wave=[ 0n 0.9 9n 0.9 10n 0 19n 0 20n 0 29n 0 30n 0 39n 0 40n 0.9 49n 0.9 50n 0.9 59n 0.9 ]
Vin169 (in169 0) vsource type=pwl wave=[ 0n 0 9n 0 10n 0.9 19n 0.9 20n 0 29n 0 30n 0 39n 0 40n 0 49n 0 50n 0 59n 0 ]
Vin168 (in168 0) vsource type=pwl wave=[ 0n 0 9n 0 10n 0 19n 0 20n 0.9 29n 0.9 30n 0 39n 0 40n 0 49n 0 50n 0 59n 0 ]
Vin167 (in167 0) vsource type=pwl wave=[ 0n 0 9n 0 10n 0 19n 0 20n 0 29n 0 30n 0.9 39n 0.9 40n 0 49n 0 50n 0 59n 0 ]
Vin166 (in166 0) vsource type=pwl wave=[ 0n 0 9n 0 10n 0 19n 0 20n 0 29n 0 30n 0 39n 0 40n 0 49n 0 50n 0 59n 0 ]
Vin165 (in165 0) vsource type=pwl wave=[ 0n 0.9 9n 0.9 10n 0 19n 0 20n 0 29n 0 30n 0 39n 0 40n 0.9 49n 0.9 50n 0.9 59n 0.9 ]
Vin164 (in164 0) vsource type=pwl wave=[ 0n 0 9n 0 10n 0.9 19n 0.9 20n 0 29n 0 30n 0 39n 0 40n 0 49n 0 50n 0 59n 0 ]
Vin163 (in163 0) vsource type=pwl wave=[ 0n 0 9n 0 10n 0 19n 0 20n 0.9 29n 0.9 30n 0 39n 0 40n 0 49n 0 50n 0 59n 0 ]
Vin162 (in162 0) vsource type=pwl wave=[ 0n 0 9n 0 10n 0 19n 0 20n 0 29n 0 30n 0.9 39n 0.9 40n 0 49n 0 50n 0 59n 0 ]
Vin161 (in161 0) vsource type=pwl wave=[ 0n 0 9n 0 10n 0 19n 0 20n 0 29n 0 30n 0 39n 0 40n 0 49n 0 50n 0 59n 0 ]
Vin160 (in160 0) vsource type=pwl wave=[ 0n 0.9 9n 0.9 10n 0 19n 0 20n 0 29n 0 30n 0 39n 0 40n 0.9 49n 0.9 50n 0.9 59n 0.9 ]
Vin159 (in159 0) vsource type=pwl wave=[ 0n 0 9n 0 10n 0.9 19n 0.9 20n 0 29n 0 30n 0 39n 0 40n 0 49n 0 50n 0 59n 0 ]
Vin158 (in158 0) vsource type=pwl wave=[ 0n 0 9n 0 10n 0 19n 0 20n 0.9 29n 0.9 30n 0 39n 0 40n 0 49n 0 50n 0 59n 0 ]
Vin157 (in157 0) vsource type=pwl wave=[ 0n 0 9n 0 10n 0 19n 0 20n 0 29n 0 30n 0.9 39n 0.9 40n 0 49n 0 50n 0 59n 0 ]
Vin156 (in156 0) vsource type=pwl wave=[ 0n 0 9n 0 10n 0 19n 0 20n 0 29n 0 30n 0 39n 0 40n 0 49n 0 50n 0 59n 0 ]
Vin155 (in155 0) vsource type=pwl wave=[ 0n 0.9 9n 0.9 10n 0 19n 0 20n 0 29n 0 30n 0 39n 0 40n 0.9 49n 0.9 50n 0.9 59n 0.9 ]
Vin154 (in154 0) vsource type=pwl wave=[ 0n 0 9n 0 10n 0.9 19n 0.9 20n 0 29n 0 30n 0 39n 0 40n 0 49n 0 50n 0 59n 0 ]
Vin153 (in153 0) vsource type=pwl wave=[ 0n 0 9n 0 10n 0 19n 0 20n 0.9 29n 0.9 30n 0 39n 0 40n 0 49n 0 50n 0 59n 0 ]
Vin152 (in152 0) vsource type=pwl wave=[ 0n 0 9n 0 10n 0 19n 0 20n 0 29n 0 30n 0.9 39n 0.9 40n 0 49n 0 50n 0 59n 0 ]
Vin151 (in151 0) vsource type=pwl wave=[ 0n 0 9n 0 10n 0 19n 0 20n 0 29n 0 30n 0 39n 0 40n 0 49n 0 50n 0 59n 0 ]
Vin150 (in150 0) vsource type=pwl wave=[ 0n 0.9 9n 0.9 10n 0 19n 0 20n 0 29n 0 30n 0 39n 0 40n 0.9 49n 0.9 50n 0.9 59n 0.9 ]
Vin149 (in149 0) vsource type=pwl wave=[ 0n 0 9n 0 10n 0.9 19n 0.9 20n 0 29n 0 30n 0 39n 0 40n 0 49n 0 50n 0 59n 0 ]
Vin148 (in148 0) vsource type=pwl wave=[ 0n 0 9n 0 10n 0 19n 0 20n 0.9 29n 0.9 30n 0 39n 0 40n 0 49n 0 50n 0 59n 0 ]
Vin147 (in147 0) vsource type=pwl wave=[ 0n 0 9n 0 10n 0 19n 0 20n 0 29n 0 30n 0.9 39n 0.9 40n 0 49n 0 50n 0 59n 0 ]
Vin146 (in146 0) vsource type=pwl wave=[ 0n 0 9n 0 10n 0 19n 0 20n 0 29n 0 30n 0 39n 0 40n 0 49n 0 50n 0 59n 0 ]
Vin145 (in145 0) vsource type=pwl wave=[ 0n 0.9 9n 0.9 10n 0 19n 0 20n 0 29n 0 30n 0 39n 0 40n 0.9 49n 0.9 50n 0.9 59n 0.9 ]
Vin144 (in144 0) vsource type=pwl wave=[ 0n 0 9n 0 10n 0.9 19n 0.9 20n 0 29n 0 30n 0 39n 0 40n 0 49n 0 50n 0 59n 0 ]
Vin143 (in143 0) vsource type=pwl wave=[ 0n 0 9n 0 10n 0 19n 0 20n 0.9 29n 0.9 30n 0 39n 0 40n 0 49n 0 50n 0 59n 0 ]
Vin142 (in142 0) vsource type=pwl wave=[ 0n 0 9n 0 10n 0 19n 0 20n 0 29n 0 30n 0.9 39n 0.9 40n 0 49n 0 50n 0 59n 0 ]
Vin141 (in141 0) vsource type=pwl wave=[ 0n 0 9n 0 10n 0 19n 0 20n 0 29n 0 30n 0 39n 0 40n 0 49n 0 50n 0 59n 0 ]
Vin140 (in140 0) vsource type=pwl wave=[ 0n 0.9 9n 0.9 10n 0 19n 0 20n 0 29n 0 30n 0 39n 0 40n 0.9 49n 0.9 50n 0.9 59n 0.9 ]
Vin139 (in139 0) vsource type=pwl wave=[ 0n 0 9n 0 10n 0.9 19n 0.9 20n 0 29n 0 30n 0 39n 0 40n 0 49n 0 50n 0 59n 0 ]
Vin138 (in138 0) vsource type=pwl wave=[ 0n 0 9n 0 10n 0 19n 0 20n 0.9 29n 0.9 30n 0 39n 0 40n 0 49n 0 50n 0 59n 0 ]
Vin137 (in137 0) vsource type=pwl wave=[ 0n 0 9n 0 10n 0 19n 0 20n 0 29n 0 30n 0.9 39n 0.9 40n 0 49n 0 50n 0 59n 0 ]
Vin136 (in136 0) vsource type=pwl wave=[ 0n 0 9n 0 10n 0 19n 0 20n 0 29n 0 30n 0 39n 0 40n 0 49n 0 50n 0 59n 0 ]
Vin135 (in135 0) vsource type=pwl wave=[ 0n 0.9 9n 0.9 10n 0 19n 0 20n 0 29n 0 30n 0 39n 0 40n 0.9 49n 0.9 50n 0.9 59n 0.9 ]
Vin134 (in134 0) vsource type=pwl wave=[ 0n 0 9n 0 10n 0.9 19n 0.9 20n 0 29n 0 30n 0 39n 0 40n 0 49n 0 50n 0 59n 0 ]
Vin133 (in133 0) vsource type=pwl wave=[ 0n 0 9n 0 10n 0 19n 0 20n 0.9 29n 0.9 30n 0 39n 0 40n 0 49n 0 50n 0 59n 0 ]
Vin132 (in132 0) vsource type=pwl wave=[ 0n 0 9n 0 10n 0 19n 0 20n 0 29n 0 30n 0.9 39n 0.9 40n 0 49n 0 50n 0 59n 0 ]
Vin131 (in131 0) vsource type=pwl wave=[ 0n 0 9n 0 10n 0 19n 0 20n 0 29n 0 30n 0 39n 0 40n 0 49n 0 50n 0 59n 0 ]
Vin130 (in130 0) vsource type=pwl wave=[ 0n 0.9 9n 0.9 10n 0 19n 0 20n 0 29n 0 30n 0 39n 0 40n 0.9 49n 0.9 50n 0.9 59n 0.9 ]
Vin129 (in129 0) vsource type=pwl wave=[ 0n 0 9n 0 10n 0.9 19n 0.9 20n 0 29n 0 30n 0 39n 0 40n 0 49n 0 50n 0 59n 0 ]
Vin128 (in128 0) vsource type=pwl wave=[ 0n 0 9n 0 10n 0.9 19n 0.9 20n 0.9 29n 0.9 30n 0.9 39n 0.9 40n 0 49n 0 50n 0.9 59n 0.9 ]
Vin127 (in127 0) vsource type=pwl wave=[ 0n 0 9n 0 10n 0.9 19n 0.9 20n 0 29n 0 30n 0.9 39n 0.9 40n 0 49n 0 50n 0.9 59n 0.9 ]
Vin126 (in126 0) vsource type=pwl wave=[ 0n 0 9n 0 10n 0 19n 0 20n 0 29n 0 30n 0 39n 0 40n 0 49n 0 50n 0 59n 0 ]
Vin125 (in125 0) vsource type=pwl wave=[ 0n 0.9 9n 0.9 10n 0 19n 0 20n 0 29n 0 30n 0 39n 0 40n 0.9 49n 0.9 50n 0.9 59n 0.9 ]
Vin124 (in124 0) vsource type=pwl wave=[ 0n 0 9n 0 10n 0.9 19n 0.9 20n 0 29n 0 30n 0 39n 0 40n 0 49n 0 50n 0 59n 0 ]
Vin123 (in123 0) vsource type=pwl wave=[ 0n 0 9n 0 10n 0 19n 0 20n 0.9 29n 0.9 30n 0 39n 0 40n 0 49n 0 50n 0 59n 0 ]
Vin122 (in122 0) vsource type=pwl wave=[ 0n 0 9n 0 10n 0 19n 0 20n 0 29n 0 30n 0.9 39n 0.9 40n 0 49n 0 50n 0 59n 0 ]
Vin121 (in121 0) vsource type=pwl wave=[ 0n 0 9n 0 10n 0 19n 0 20n 0 29n 0 30n 0 39n 0 40n 0 49n 0 50n 0 59n 0 ]
Vin120 (in120 0) vsource type=pwl wave=[ 0n 0.9 9n 0.9 10n 0 19n 0 20n 0 29n 0 30n 0 39n 0 40n 0.9 49n 0.9 50n 0.9 59n 0.9 ]
Vin119 (in119 0) vsource type=pwl wave=[ 0n 0 9n 0 10n 0.9 19n 0.9 20n 0 29n 0 30n 0 39n 0 40n 0 49n 0 50n 0 59n 0 ]
Vin118 (in118 0) vsource type=pwl wave=[ 0n 0 9n 0 10n 0 19n 0 20n 0.9 29n 0.9 30n 0 39n 0 40n 0 49n 0 50n 0 59n 0 ]
Vin117 (in117 0) vsource type=pwl wave=[ 0n 0 9n 0 10n 0 19n 0 20n 0 29n 0 30n 0.9 39n 0.9 40n 0 49n 0 50n 0 59n 0 ]
Vin116 (in116 0) vsource type=pwl wave=[ 0n 0 9n 0 10n 0 19n 0 20n 0 29n 0 30n 0 39n 0 40n 0 49n 0 50n 0 59n 0 ]
Vin115 (in115 0) vsource type=pwl wave=[ 0n 0.9 9n 0.9 10n 0 19n 0 20n 0 29n 0 30n 0 39n 0 40n 0.9 49n 0.9 50n 0.9 59n 0.9 ]
Vin114 (in114 0) vsource type=pwl wave=[ 0n 0 9n 0 10n 0.9 19n 0.9 20n 0 29n 0 30n 0 39n 0 40n 0 49n 0 50n 0 59n 0 ]
Vin113 (in113 0) vsource type=pwl wave=[ 0n 0 9n 0 10n 0 19n 0 20n 0.9 29n 0.9 30n 0 39n 0 40n 0 49n 0 50n 0 59n 0 ]
Vin112 (in112 0) vsource type=pwl wave=[ 0n 0 9n 0 10n 0 19n 0 20n 0 29n 0 30n 0.9 39n 0.9 40n 0 49n 0 50n 0 59n 0 ]
Vin111 (in111 0) vsource type=pwl wave=[ 0n 0 9n 0 10n 0 19n 0 20n 0 29n 0 30n 0 39n 0 40n 0 49n 0 50n 0 59n 0 ]
Vin110 (in110 0) vsource type=pwl wave=[ 0n 0.9 9n 0.9 10n 0 19n 0 20n 0 29n 0 30n 0 39n 0 40n 0.9 49n 0.9 50n 0.9 59n 0.9 ]
Vin109 (in109 0) vsource type=pwl wave=[ 0n 0 9n 0 10n 0.9 19n 0.9 20n 0 29n 0 30n 0 39n 0 40n 0 49n 0 50n 0 59n 0 ]
Vin108 (in108 0) vsource type=pwl wave=[ 0n 0 9n 0 10n 0 19n 0 20n 0.9 29n 0.9 30n 0 39n 0 40n 0 49n 0 50n 0 59n 0 ]
Vin107 (in107 0) vsource type=pwl wave=[ 0n 0 9n 0 10n 0 19n 0 20n 0 29n 0 30n 0.9 39n 0.9 40n 0 49n 0 50n 0 59n 0 ]
Vin106 (in106 0) vsource type=pwl wave=[ 0n 0 9n 0 10n 0 19n 0 20n 0 29n 0 30n 0 39n 0 40n 0 49n 0 50n 0 59n 0 ]
Vin105 (in105 0) vsource type=pwl wave=[ 0n 0.9 9n 0.9 10n 0 19n 0 20n 0 29n 0 30n 0 39n 0 40n 0.9 49n 0.9 50n 0.9 59n 0.9 ]
Vin104 (in104 0) vsource type=pwl wave=[ 0n 0 9n 0 10n 0.9 19n 0.9 20n 0 29n 0 30n 0 39n 0 40n 0 49n 0 50n 0 59n 0 ]
Vin103 (in103 0) vsource type=pwl wave=[ 0n 0 9n 0 10n 0 19n 0 20n 0.9 29n 0.9 30n 0 39n 0 40n 0 49n 0 50n 0 59n 0 ]
Vin102 (in102 0) vsource type=pwl wave=[ 0n 0 9n 0 10n 0 19n 0 20n 0 29n 0 30n 0.9 39n 0.9 40n 0 49n 0 50n 0 59n 0 ]
Vin101 (in101 0) vsource type=pwl wave=[ 0n 0 9n 0 10n 0 19n 0 20n 0 29n 0 30n 0 39n 0 40n 0 49n 0 50n 0 59n 0 ]
Vin100 (in100 0) vsource type=pwl wave=[ 0n 0.9 9n 0.9 10n 0 19n 0 20n 0 29n 0 30n 0 39n 0 40n 0.9 49n 0.9 50n 0.9 59n 0.9 ]
Vin99 (in99 0) vsource type=pwl wave=[ 0n 0 9n 0 10n 0.9 19n 0.9 20n 0 29n 0 30n 0 39n 0 40n 0 49n 0 50n 0 59n 0 ]
Vin98 (in98 0) vsource type=pwl wave=[ 0n 0 9n 0 10n 0 19n 0 20n 0.9 29n 0.9 30n 0 39n 0 40n 0 49n 0 50n 0 59n 0 ]
Vin97 (in97 0) vsource type=pwl wave=[ 0n 0 9n 0 10n 0 19n 0 20n 0 29n 0 30n 0.9 39n 0.9 40n 0 49n 0 50n 0 59n 0 ]
Vin96 (in96 0) vsource type=pwl wave=[ 0n 0 9n 0 10n 0 19n 0 20n 0 29n 0 30n 0 39n 0 40n 0 49n 0 50n 0 59n 0 ]
Vin95 (in95 0) vsource type=pwl wave=[ 0n 0.9 9n 0.9 10n 0 19n 0 20n 0 29n 0 30n 0 39n 0 40n 0.9 49n 0.9 50n 0.9 59n 0.9 ]
Vin94 (in94 0) vsource type=pwl wave=[ 0n 0 9n 0 10n 0.9 19n 0.9 20n 0 29n 0 30n 0 39n 0 40n 0 49n 0 50n 0 59n 0 ]
Vin93 (in93 0) vsource type=pwl wave=[ 0n 0 9n 0 10n 0 19n 0 20n 0.9 29n 0.9 30n 0 39n 0 40n 0 49n 0 50n 0 59n 0 ]
Vin92 (in92 0) vsource type=pwl wave=[ 0n 0 9n 0 10n 0 19n 0 20n 0 29n 0 30n 0.9 39n 0.9 40n 0 49n 0 50n 0 59n 0 ]
Vin91 (in91 0) vsource type=pwl wave=[ 0n 0 9n 0 10n 0 19n 0 20n 0 29n 0 30n 0 39n 0 40n 0 49n 0 50n 0 59n 0 ]
Vin90 (in90 0) vsource type=pwl wave=[ 0n 0.9 9n 0.9 10n 0 19n 0 20n 0 29n 0 30n 0 39n 0 40n 0.9 49n 0.9 50n 0.9 59n 0.9 ]
Vin89 (in89 0) vsource type=pwl wave=[ 0n 0 9n 0 10n 0.9 19n 0.9 20n 0 29n 0 30n 0 39n 0 40n 0 49n 0 50n 0 59n 0 ]
Vin88 (in88 0) vsource type=pwl wave=[ 0n 0 9n 0 10n 0 19n 0 20n 0.9 29n 0.9 30n 0 39n 0 40n 0 49n 0 50n 0 59n 0 ]
Vin87 (in87 0) vsource type=pwl wave=[ 0n 0 9n 0 10n 0 19n 0 20n 0 29n 0 30n 0.9 39n 0.9 40n 0 49n 0 50n 0 59n 0 ]
Vin86 (in86 0) vsource type=pwl wave=[ 0n 0 9n 0 10n 0 19n 0 20n 0 29n 0 30n 0 39n 0 40n 0 49n 0 50n 0 59n 0 ]
Vin85 (in85 0) vsource type=pwl wave=[ 0n 0.9 9n 0.9 10n 0 19n 0 20n 0 29n 0 30n 0 39n 0 40n 0.9 49n 0.9 50n 0.9 59n 0.9 ]
Vin84 (in84 0) vsource type=pwl wave=[ 0n 0 9n 0 10n 0.9 19n 0.9 20n 0 29n 0 30n 0 39n 0 40n 0 49n 0 50n 0 59n 0 ]
Vin83 (in83 0) vsource type=pwl wave=[ 0n 0 9n 0 10n 0 19n 0 20n 0.9 29n 0.9 30n 0 39n 0 40n 0 49n 0 50n 0 59n 0 ]
Vin82 (in82 0) vsource type=pwl wave=[ 0n 0 9n 0 10n 0 19n 0 20n 0 29n 0 30n 0.9 39n 0.9 40n 0 49n 0 50n 0 59n 0 ]
Vin81 (in81 0) vsource type=pwl wave=[ 0n 0 9n 0 10n 0 19n 0 20n 0 29n 0 30n 0 39n 0 40n 0 49n 0 50n 0 59n 0 ]
Vin80 (in80 0) vsource type=pwl wave=[ 0n 0.9 9n 0.9 10n 0 19n 0 20n 0 29n 0 30n 0 39n 0 40n 0.9 49n 0.9 50n 0.9 59n 0.9 ]
Vin79 (in79 0) vsource type=pwl wave=[ 0n 0 9n 0 10n 0.9 19n 0.9 20n 0 29n 0 30n 0 39n 0 40n 0 49n 0 50n 0 59n 0 ]
Vin78 (in78 0) vsource type=pwl wave=[ 0n 0 9n 0 10n 0 19n 0 20n 0.9 29n 0.9 30n 0 39n 0 40n 0 49n 0 50n 0 59n 0 ]
Vin77 (in77 0) vsource type=pwl wave=[ 0n 0 9n 0 10n 0 19n 0 20n 0 29n 0 30n 0.9 39n 0.9 40n 0 49n 0 50n 0 59n 0 ]
Vin76 (in76 0) vsource type=pwl wave=[ 0n 0 9n 0 10n 0 19n 0 20n 0 29n 0 30n 0 39n 0 40n 0 49n 0 50n 0 59n 0 ]
Vin75 (in75 0) vsource type=pwl wave=[ 0n 0.9 9n 0.9 10n 0 19n 0 20n 0 29n 0 30n 0 39n 0 40n 0.9 49n 0.9 50n 0.9 59n 0.9 ]
Vin74 (in74 0) vsource type=pwl wave=[ 0n 0 9n 0 10n 0.9 19n 0.9 20n 0 29n 0 30n 0 39n 0 40n 0 49n 0 50n 0 59n 0 ]
Vin73 (in73 0) vsource type=pwl wave=[ 0n 0 9n 0 10n 0 19n 0 20n 0.9 29n 0.9 30n 0 39n 0 40n 0 49n 0 50n 0 59n 0 ]
Vin72 (in72 0) vsource type=pwl wave=[ 0n 0 9n 0 10n 0 19n 0 20n 0 29n 0 30n 0.9 39n 0.9 40n 0 49n 0 50n 0 59n 0 ]
Vin71 (in71 0) vsource type=pwl wave=[ 0n 0 9n 0 10n 0 19n 0 20n 0 29n 0 30n 0 39n 0 40n 0 49n 0 50n 0 59n 0 ]
Vin70 (in70 0) vsource type=pwl wave=[ 0n 0.9 9n 0.9 10n 0 19n 0 20n 0 29n 0 30n 0 39n 0 40n 0.9 49n 0.9 50n 0.9 59n 0.9 ]
Vin69 (in69 0) vsource type=pwl wave=[ 0n 0 9n 0 10n 0.9 19n 0.9 20n 0 29n 0 30n 0 39n 0 40n 0 49n 0 50n 0 59n 0 ]
Vin68 (in68 0) vsource type=pwl wave=[ 0n 0 9n 0 10n 0 19n 0 20n 0.9 29n 0.9 30n 0 39n 0 40n 0 49n 0 50n 0 59n 0 ]
Vin67 (in67 0) vsource type=pwl wave=[ 0n 0 9n 0 10n 0 19n 0 20n 0 29n 0 30n 0.9 39n 0.9 40n 0 49n 0 50n 0 59n 0 ]
Vin66 (in66 0) vsource type=pwl wave=[ 0n 0 9n 0 10n 0 19n 0 20n 0 29n 0 30n 0 39n 0 40n 0 49n 0 50n 0 59n 0 ]
Vin65 (in65 0) vsource type=pwl wave=[ 0n 0.9 9n 0.9 10n 0 19n 0 20n 0 29n 0 30n 0 39n 0 40n 0.9 49n 0.9 50n 0.9 59n 0.9 ]
Vin64 (in64 0) vsource type=pwl wave=[ 0n 0 9n 0 10n 0.9 19n 0.9 20n 0 29n 0 30n 0 39n 0 40n 0 49n 0 50n 0 59n 0 ]
Vin63 (in63 0) vsource type=pwl wave=[ 0n 0 9n 0 10n 0 19n 0 20n 0.9 29n 0.9 30n 0 39n 0 40n 0 49n 0 50n 0 59n 0 ]
Vin62 (in62 0) vsource type=pwl wave=[ 0n 0 9n 0 10n 0 19n 0 20n 0 29n 0 30n 0.9 39n 0.9 40n 0 49n 0 50n 0 59n 0 ]
Vin61 (in61 0) vsource type=pwl wave=[ 0n 0 9n 0 10n 0 19n 0 20n 0 29n 0 30n 0 39n 0 40n 0 49n 0 50n 0 59n 0 ]
Vin60 (in60 0) vsource type=pwl wave=[ 0n 0.9 9n 0.9 10n 0 19n 0 20n 0 29n 0 30n 0 39n 0 40n 0.9 49n 0.9 50n 0.9 59n 0.9 ]
Vin59 (in59 0) vsource type=pwl wave=[ 0n 0 9n 0 10n 0.9 19n 0.9 20n 0 29n 0 30n 0 39n 0 40n 0 49n 0 50n 0 59n 0 ]
Vin58 (in58 0) vsource type=pwl wave=[ 0n 0 9n 0 10n 0 19n 0 20n 0.9 29n 0.9 30n 0 39n 0 40n 0 49n 0 50n 0 59n 0 ]
Vin57 (in57 0) vsource type=pwl wave=[ 0n 0 9n 0 10n 0 19n 0 20n 0 29n 0 30n 0.9 39n 0.9 40n 0 49n 0 50n 0 59n 0 ]
Vin56 (in56 0) vsource type=pwl wave=[ 0n 0 9n 0 10n 0 19n 0 20n 0 29n 0 30n 0 39n 0 40n 0 49n 0 50n 0 59n 0 ]
Vin55 (in55 0) vsource type=pwl wave=[ 0n 0.9 9n 0.9 10n 0 19n 0 20n 0 29n 0 30n 0 39n 0 40n 0.9 49n 0.9 50n 0.9 59n 0.9 ]
Vin54 (in54 0) vsource type=pwl wave=[ 0n 0 9n 0 10n 0.9 19n 0.9 20n 0 29n 0 30n 0 39n 0 40n 0 49n 0 50n 0 59n 0 ]
Vin53 (in53 0) vsource type=pwl wave=[ 0n 0 9n 0 10n 0 19n 0 20n 0.9 29n 0.9 30n 0 39n 0 40n 0 49n 0 50n 0 59n 0 ]
Vin52 (in52 0) vsource type=pwl wave=[ 0n 0 9n 0 10n 0 19n 0 20n 0 29n 0 30n 0.9 39n 0.9 40n 0 49n 0 50n 0 59n 0 ]
Vin51 (in51 0) vsource type=pwl wave=[ 0n 0 9n 0 10n 0 19n 0 20n 0 29n 0 30n 0 39n 0 40n 0 49n 0 50n 0 59n 0 ]
Vin50 (in50 0) vsource type=pwl wave=[ 0n 0.9 9n 0.9 10n 0 19n 0 20n 0 29n 0 30n 0 39n 0 40n 0.9 49n 0.9 50n 0.9 59n 0.9 ]
Vin49 (in49 0) vsource type=pwl wave=[ 0n 0 9n 0 10n 0.9 19n 0.9 20n 0 29n 0 30n 0 39n 0 40n 0 49n 0 50n 0 59n 0 ]
Vin48 (in48 0) vsource type=pwl wave=[ 0n 0 9n 0 10n 0 19n 0 20n 0.9 29n 0.9 30n 0 39n 0 40n 0 49n 0 50n 0 59n 0 ]
Vin47 (in47 0) vsource type=pwl wave=[ 0n 0 9n 0 10n 0 19n 0 20n 0 29n 0 30n 0.9 39n 0.9 40n 0 49n 0 50n 0 59n 0 ]
Vin46 (in46 0) vsource type=pwl wave=[ 0n 0 9n 0 10n 0 19n 0 20n 0 29n 0 30n 0 39n 0 40n 0 49n 0 50n 0 59n 0 ]
Vin45 (in45 0) vsource type=pwl wave=[ 0n 0.9 9n 0.9 10n 0 19n 0 20n 0 29n 0 30n 0 39n 0 40n 0.9 49n 0.9 50n 0.9 59n 0.9 ]
Vin44 (in44 0) vsource type=pwl wave=[ 0n 0 9n 0 10n 0.9 19n 0.9 20n 0 29n 0 30n 0 39n 0 40n 0 49n 0 50n 0 59n 0 ]
Vin43 (in43 0) vsource type=pwl wave=[ 0n 0 9n 0 10n 0 19n 0 20n 0.9 29n 0.9 30n 0 39n 0 40n 0 49n 0 50n 0 59n 0 ]
Vin42 (in42 0) vsource type=pwl wave=[ 0n 0 9n 0 10n 0 19n 0 20n 0 29n 0 30n 0.9 39n 0.9 40n 0 49n 0 50n 0 59n 0 ]
Vin41 (in41 0) vsource type=pwl wave=[ 0n 0 9n 0 10n 0 19n 0 20n 0 29n 0 30n 0 39n 0 40n 0 49n 0 50n 0 59n 0 ]
Vin40 (in40 0) vsource type=pwl wave=[ 0n 0.9 9n 0.9 10n 0 19n 0 20n 0 29n 0 30n 0 39n 0 40n 0.9 49n 0.9 50n 0.9 59n 0.9 ]
Vin39 (in39 0) vsource type=pwl wave=[ 0n 0 9n 0 10n 0.9 19n 0.9 20n 0 29n 0 30n 0 39n 0 40n 0 49n 0 50n 0 59n 0 ]
Vin38 (in38 0) vsource type=pwl wave=[ 0n 0 9n 0 10n 0 19n 0 20n 0.9 29n 0.9 30n 0 39n 0 40n 0 49n 0 50n 0 59n 0 ]
Vin37 (in37 0) vsource type=pwl wave=[ 0n 0 9n 0 10n 0 19n 0 20n 0 29n 0 30n 0.9 39n 0.9 40n 0 49n 0 50n 0 59n 0 ]
Vin36 (in36 0) vsource type=pwl wave=[ 0n 0 9n 0 10n 0 19n 0 20n 0 29n 0 30n 0 39n 0 40n 0 49n 0 50n 0 59n 0 ]
Vin35 (in35 0) vsource type=pwl wave=[ 0n 0.9 9n 0.9 10n 0 19n 0 20n 0 29n 0 30n 0 39n 0 40n 0.9 49n 0.9 50n 0.9 59n 0.9 ]
Vin34 (in34 0) vsource type=pwl wave=[ 0n 0 9n 0 10n 0.9 19n 0.9 20n 0 29n 0 30n 0 39n 0 40n 0 49n 0 50n 0 59n 0 ]
Vin33 (in33 0) vsource type=pwl wave=[ 0n 0 9n 0 10n 0 19n 0 20n 0.9 29n 0.9 30n 0 39n 0 40n 0 49n 0 50n 0 59n 0 ]
Vin32 (in32 0) vsource type=pwl wave=[ 0n 0 9n 0 10n 0 19n 0 20n 0 29n 0 30n 0.9 39n 0.9 40n 0 49n 0 50n 0 59n 0 ]
Vin31 (in31 0) vsource type=pwl wave=[ 0n 0 9n 0 10n 0 19n 0 20n 0 29n 0 30n 0 39n 0 40n 0 49n 0 50n 0 59n 0 ]
Vin30 (in30 0) vsource type=pwl wave=[ 0n 0.9 9n 0.9 10n 0 19n 0 20n 0 29n 0 30n 0 39n 0 40n 0.9 49n 0.9 50n 0.9 59n 0.9 ]
Vin29 (in29 0) vsource type=pwl wave=[ 0n 0 9n 0 10n 0.9 19n 0.9 20n 0 29n 0 30n 0 39n 0 40n 0 49n 0 50n 0 59n 0 ]
Vin28 (in28 0) vsource type=pwl wave=[ 0n 0 9n 0 10n 0 19n 0 20n 0.9 29n 0.9 30n 0 39n 0 40n 0 49n 0 50n 0 59n 0 ]
Vin27 (in27 0) vsource type=pwl wave=[ 0n 0 9n 0 10n 0 19n 0 20n 0 29n 0 30n 0.9 39n 0.9 40n 0 49n 0 50n 0 59n 0 ]
Vin26 (in26 0) vsource type=pwl wave=[ 0n 0 9n 0 10n 0 19n 0 20n 0 29n 0 30n 0 39n 0 40n 0 49n 0 50n 0 59n 0 ]
Vin25 (in25 0) vsource type=pwl wave=[ 0n 0.9 9n 0.9 10n 0 19n 0 20n 0 29n 0 30n 0 39n 0 40n 0.9 49n 0.9 50n 0.9 59n 0.9 ]
Vin24 (in24 0) vsource type=pwl wave=[ 0n 0 9n 0 10n 0.9 19n 0.9 20n 0 29n 0 30n 0 39n 0 40n 0 49n 0 50n 0 59n 0 ]
Vin23 (in23 0) vsource type=pwl wave=[ 0n 0 9n 0 10n 0 19n 0 20n 0.9 29n 0.9 30n 0 39n 0 40n 0 49n 0 50n 0 59n 0 ]
Vin22 (in22 0) vsource type=pwl wave=[ 0n 0 9n 0 10n 0 19n 0 20n 0 29n 0 30n 0.9 39n 0.9 40n 0 49n 0 50n 0 59n 0 ]
Vin21 (in21 0) vsource type=pwl wave=[ 0n 0 9n 0 10n 0 19n 0 20n 0 29n 0 30n 0 39n 0 40n 0 49n 0 50n 0 59n 0 ]
Vin20 (in20 0) vsource type=pwl wave=[ 0n 0.9 9n 0.9 10n 0 19n 0 20n 0 29n 0 30n 0 39n 0 40n 0.9 49n 0.9 50n 0.9 59n 0.9 ]
Vin19 (in19 0) vsource type=pwl wave=[ 0n 0 9n 0 10n 0.9 19n 0.9 20n 0 29n 0 30n 0 39n 0 40n 0 49n 0 50n 0 59n 0 ]
Vin18 (in18 0) vsource type=pwl wave=[ 0n 0 9n 0 10n 0 19n 0 20n 0.9 29n 0.9 30n 0 39n 0 40n 0 49n 0 50n 0 59n 0 ]
Vin17 (in17 0) vsource type=pwl wave=[ 0n 0 9n 0 10n 0 19n 0 20n 0 29n 0 30n 0.9 39n 0.9 40n 0 49n 0 50n 0 59n 0 ]
Vin16 (in16 0) vsource type=pwl wave=[ 0n 0 9n 0 10n 0 19n 0 20n 0 29n 0 30n 0 39n 0 40n 0 49n 0 50n 0 59n 0 ]
Vin15 (in15 0) vsource type=pwl wave=[ 0n 0.9 9n 0.9 10n 0 19n 0 20n 0 29n 0 30n 0 39n 0 40n 0.9 49n 0.9 50n 0.9 59n 0.9 ]
Vin14 (in14 0) vsource type=pwl wave=[ 0n 0 9n 0 10n 0.9 19n 0.9 20n 0 29n 0 30n 0 39n 0 40n 0 49n 0 50n 0 59n 0 ]
Vin13 (in13 0) vsource type=pwl wave=[ 0n 0 9n 0 10n 0 19n 0 20n 0.9 29n 0.9 30n 0 39n 0 40n 0 49n 0 50n 0 59n 0 ]
Vin12 (in12 0) vsource type=pwl wave=[ 0n 0 9n 0 10n 0 19n 0 20n 0 29n 0 30n 0.9 39n 0.9 40n 0 49n 0 50n 0 59n 0 ]
Vin11 (in11 0) vsource type=pwl wave=[ 0n 0 9n 0 10n 0 19n 0 20n 0 29n 0 30n 0 39n 0 40n 0 49n 0 50n 0 59n 0 ]
Vin10 (in10 0) vsource type=pwl wave=[ 0n 0.9 9n 0.9 10n 0 19n 0 20n 0 29n 0 30n 0 39n 0 40n 0.9 49n 0.9 50n 0.9 59n 0.9 ]
Vin9 (in9 0) vsource type=pwl wave=[ 0n 0 9n 0 10n 0.9 19n 0.9 20n 0 29n 0 30n 0 39n 0 40n 0 49n 0 50n 0 59n 0 ]
Vin8 (in8 0) vsource type=pwl wave=[ 0n 0 9n 0 10n 0 19n 0 20n 0.9 29n 0.9 30n 0 39n 0 40n 0 49n 0 50n 0 59n 0 ]
Vin7 (in7 0) vsource type=pwl wave=[ 0n 0 9n 0 10n 0 19n 0 20n 0 29n 0 30n 0.9 39n 0.9 40n 0 49n 0 50n 0 59n 0 ]
Vin6 (in6 0) vsource type=pwl wave=[ 0n 0 9n 0 10n 0 19n 0 20n 0 29n 0 30n 0 39n 0 40n 0 49n 0 50n 0 59n 0 ]
Vin5 (in5 0) vsource type=pwl wave=[ 0n 0.9 9n 0.9 10n 0 19n 0 20n 0 29n 0 30n 0 39n 0 40n 0.9 49n 0.9 50n 0.9 59n 0.9 ]
Vin4 (in4 0) vsource type=pwl wave=[ 0n 0 9n 0 10n 0.9 19n 0.9 20n 0 29n 0 30n 0 39n 0 40n 0 49n 0 50n 0 59n 0 ]
Vin3 (in3 0) vsource type=pwl wave=[ 0n 0 9n 0 10n 0 19n 0 20n 0.9 29n 0.9 30n 0 39n 0 40n 0 49n 0 50n 0 59n 0 ]
Vin2 (in2 0) vsource type=pwl wave=[ 0n 0 9n 0 10n 0 19n 0 20n 0 29n 0 30n 0.9 39n 0.9 40n 0 49n 0 50n 0 59n 0 ]
Vin1 (in1 0) vsource type=pwl wave=[ 0n 0 9n 0 10n 0.9 19n 0.9 20n 0 29n 0 30n 0.9 39n 0.9 40n 0 49n 0 50n 0.9 59n 0.9 ]
Vin0 (in0 0) vsource type=pwl wave=[ 0n 0.9 9n 0.9 10n 0.9 19n 0.9 20n 0 29n 0 30n 0.9 39n 0.9 40n 0.9 49n 0.9 50n 0.9 59n 0.9 ]

XDUT (in255 in254 in253 in252 in251 in250 in249 in248 in247 in246 in245 in244 in243 in242 in241 in240 in239 in238 in237 in236 in235 in234 in233 in232 in231 in230 in229 in228 in227 in226 in225 in224 in223 in222 in221 in220 in219 in218 in217 in216 in215 in214 in213 in212 in211 in210 in209 in208 in207 in206 in205 in204 in203 in202 in201 in200 in199 in198 in197 in196 in195 in194 in193 in192 in191 in190 in189 in188 in187 in186 in185 in184 in183 in182 in181 in180 in179 in178 in177 in176 in175 in174 in173 in172 in171 in170 in169 in168 in167 in166 in165 in164 in163 in162 in161 in160 in159 in158 in157 in156 in155 in154 in153 in152 in151 in150 in149 in148 in147 in146 in145 in144 in143 in142 in141 in140 in139 in138 in137 in136 in135 in134 in133 in132 in131 in130 in129 in128 in127 in126 in125 in124 in123 in122 in121 in120 in119 in118 in117 in116 in115 in114 in113 in112 in111 in110 in109 in108 in107 in106 in105 in104 in103 in102 in101 in100 in99 in98 in97 in96 in95 in94 in93 in92 in91 in90 in89 in88 in87 in86 in85 in84 in83 in82 in81 in80 in79 in78 in77 in76 in75 in74 in73 in72 in71 in70 in69 in68 in67 in66 in65 in64 in63 in62 in61 in60 in59 in58 in57 in56 in55 in54 in53 in52 in51 in50 in49 in48 in47 in46 in45 in44 in43 in42 in41 in40 in39 in38 in37 in36 in35 in34 in33 in32 in31 in30 in29 in28 in27 in26 in25 in24 in23 in22 in21 in20 in19 in18 in17 in16 in15 in14 in13 in12 in11 in10 in9 in8 in7 in6 in5 in4 in3 in2 in1 in0 out15_15 out15_14 out15_13 out15_12 out15_11 out15_10 out15_9 out15_8 out15_7 out15_6 out15_5 out15_4 out15_3 out15_2 out15_1 out15_0 out14_15 out14_14 out14_13 out14_12 out14_11 out14_10 out14_9 out14_8 out14_7 out14_6 out14_5 out14_4 out14_3 out14_2 out14_1 out14_0 out13_15 out13_14 out13_13 out13_12 out13_11 out13_10 out13_9 out13_8 out13_7 out13_6 out13_5 out13_4 out13_3 out13_2 out13_1 out13_0 out12_15 out12_14 out12_13 out12_12 out12_11 out12_10 out12_9 out12_8 out12_7 out12_6 out12_5 out12_4 out12_3 out12_2 out12_1 out12_0 out11_15 out11_14 out11_13 out11_12 out11_11 out11_10 out11_9 out11_8 out11_7 out11_6 out11_5 out11_4 out11_3 out11_2 out11_1 out11_0 out10_15 out10_14 out10_13 out10_12 out10_11 out10_10 out10_9 out10_8 out10_7 out10_6 out10_5 out10_4 out10_3 out10_2 out10_1 out10_0 out9_15 out9_14 out9_13 out9_12 out9_11 out9_10 out9_9 out9_8 out9_7 out9_6 out9_5 out9_4 out9_3 out9_2 out9_1 out9_0 out8_15 out8_14 out8_13 out8_12 out8_11 out8_10 out8_9 out8_8 out8_7 out8_6 out8_5 out8_4 out8_3 out8_2 out8_1 out8_0 out7_15 out7_14 out7_13 out7_12 out7_11 out7_10 out7_9 out7_8 out7_7 out7_6 out7_5 out7_4 out7_3 out7_2 out7_1 out7_0 out6_15 out6_14 out6_13 out6_12 out6_11 out6_10 out6_9 out6_8 out6_7 out6_6 out6_5 out6_4 out6_3 out6_2 out6_1 out6_0 out5_15 out5_14 out5_13 out5_12 out5_11 out5_10 out5_9 out5_8 out5_7 out5_6 out5_5 out5_4 out5_3 out5_2 out5_1 out5_0 out4_15 out4_14 out4_13 out4_12 out4_11 out4_10 out4_9 out4_8 out4_7 out4_6 out4_5 out4_4 out4_3 out4_2 out4_1 out4_0 out3_15 out3_14 out3_13 out3_12 out3_11 out3_10 out3_9 out3_8 out3_7 out3_6 out3_5 out3_4 out3_3 out3_2 out3_1 out3_0 out2_15 out2_14 out2_13 out2_12 out2_11 out2_10 out2_9 out2_8 out2_7 out2_6 out2_5 out2_4 out2_3 out2_2 out2_1 out2_0 out1_15 out1_14 out1_13 out1_12 out1_11 out1_10 out1_9 out1_8 out1_7 out1_6 out1_5 out1_4 out1_3 out1_2 out1_1 out1_0 out0_15 out0_14 out0_13 out0_12 out0_11 out0_10 out0_9 out0_8 out0_7 out0_6 out0_5 out0_4 out0_3 out0_2 out0_1 out0_0) bus_split_256_to_16x16

tran tran stop=60n maxstep=200p
save in255 in254 in253 in252 in251 in250 in249 in248 in247 in246 in245 in244 in243 in242 in241 in240 in239 in238 in237 in236 in235 in234 in233 in232 in231 in230 in229 in228 in227 in226 in225 in224 in223 in222 in221 in220 in219 in218 in217 in216 in215 in214 in213 in212 in211 in210 in209 in208 in207 in206 in205 in204 in203 in202 in201 in200 in199 in198 in197 in196 in195 in194 in193 in192 in191 in190 in189 in188 in187 in186 in185 in184 in183 in182 in181 in180 in179 in178 in177 in176 in175 in174 in173 in172 in171 in170 in169 in168 in167 in166 in165 in164 in163 in162 in161 in160 in159 in158 in157 in156 in155 in154 in153 in152 in151 in150 in149 in148 in147 in146 in145 in144 in143 in142 in141 in140 in139 in138 in137 in136 in135 in134 in133 in132 in131 in130 in129 in128 in127 in126 in125 in124 in123 in122 in121 in120 in119 in118 in117 in116 in115 in114 in113 in112 in111 in110 in109 in108 in107 in106 in105 in104 in103 in102 in101 in100 in99 in98 in97 in96 in95 in94 in93 in92 in91 in90 in89 in88 in87 in86 in85 in84 in83 in82 in81 in80 in79 in78 in77 in76 in75 in74 in73 in72 in71 in70 in69 in68 in67 in66 in65 in64 in63 in62 in61 in60 in59 in58 in57 in56 in55 in54 in53 in52 in51 in50 in49 in48 in47 in46 in45 in44 in43 in42 in41 in40 in39 in38 in37 in36 in35 in34 in33 in32 in31 in30 in29 in28 in27 in26 in25 in24 in23 in22 in21 in20 in19 in18 in17 in16 in15 in14 in13 in12 in11 in10 in9 in8 in7 in6 in5 in4 in3 in2 in1 in0 out15_15 out15_14 out15_13 out15_12 out15_11 out15_10 out15_9 out15_8 out15_7 out15_6 out15_5 out15_4 out15_3 out15_2 out15_1 out15_0 out14_15 out14_14 out14_13 out14_12 out14_11 out14_10 out14_9 out14_8 out14_7 out14_6 out14_5 out14_4 out14_3 out14_2 out14_1 out14_0 out13_15 out13_14 out13_13 out13_12 out13_11 out13_10 out13_9 out13_8 out13_7 out13_6 out13_5 out13_4 out13_3 out13_2 out13_1 out13_0 out12_15 out12_14 out12_13 out12_12 out12_11 out12_10 out12_9 out12_8 out12_7 out12_6 out12_5 out12_4 out12_3 out12_2 out12_1 out12_0 out11_15 out11_14 out11_13 out11_12 out11_11 out11_10 out11_9 out11_8 out11_7 out11_6 out11_5 out11_4 out11_3 out11_2 out11_1 out11_0 out10_15 out10_14 out10_13 out10_12 out10_11 out10_10 out10_9 out10_8 out10_7 out10_6 out10_5 out10_4 out10_3 out10_2 out10_1 out10_0 out9_15 out9_14 out9_13 out9_12 out9_11 out9_10 out9_9 out9_8 out9_7 out9_6 out9_5 out9_4 out9_3 out9_2 out9_1 out9_0 out8_15 out8_14 out8_13 out8_12 out8_11 out8_10 out8_9 out8_8 out8_7 out8_6 out8_5 out8_4 out8_3 out8_2 out8_1 out8_0 out7_15 out7_14 out7_13 out7_12 out7_11 out7_10 out7_9 out7_8 out7_7 out7_6 out7_5 out7_4 out7_3 out7_2 out7_1 out7_0 out6_15 out6_14 out6_13 out6_12 out6_11 out6_10 out6_9 out6_8 out6_7 out6_6 out6_5 out6_4 out6_3 out6_2 out6_1 out6_0 out5_15 out5_14 out5_13 out5_12 out5_11 out5_10 out5_9 out5_8 out5_7 out5_6 out5_5 out5_4 out5_3 out5_2 out5_1 out5_0 out4_15 out4_14 out4_13 out4_12 out4_11 out4_10 out4_9 out4_8 out4_7 out4_6 out4_5 out4_4 out4_3 out4_2 out4_1 out4_0 out3_15 out3_14 out3_13 out3_12 out3_11 out3_10 out3_9 out3_8 out3_7 out3_6 out3_5 out3_4 out3_3 out3_2 out3_1 out3_0 out2_15 out2_14 out2_13 out2_12 out2_11 out2_10 out2_9 out2_8 out2_7 out2_6 out2_5 out2_4 out2_3 out2_2 out2_1 out2_0 out1_15 out1_14 out1_13 out1_12 out1_11 out1_10 out1_9 out1_8 out1_7 out1_6 out1_5 out1_4 out1_3 out1_2 out1_1 out1_0 out0_15 out0_14 out0_13 out0_12 out0_11 out0_10 out0_9 out0_8 out0_7 out0_6 out0_5 out0_4 out0_3 out0_2 out0_1 out0_0
