`include "constants.vams"
`include "disciplines.vams"

module bus_split_256_to_16x16(
    in255,
    in254,
    in253,
    in252,
    in251,
    in250,
    in249,
    in248,
    in247,
    in246,
    in245,
    in244,
    in243,
    in242,
    in241,
    in240,
    in239,
    in238,
    in237,
    in236,
    in235,
    in234,
    in233,
    in232,
    in231,
    in230,
    in229,
    in228,
    in227,
    in226,
    in225,
    in224,
    in223,
    in222,
    in221,
    in220,
    in219,
    in218,
    in217,
    in216,
    in215,
    in214,
    in213,
    in212,
    in211,
    in210,
    in209,
    in208,
    in207,
    in206,
    in205,
    in204,
    in203,
    in202,
    in201,
    in200,
    in199,
    in198,
    in197,
    in196,
    in195,
    in194,
    in193,
    in192,
    in191,
    in190,
    in189,
    in188,
    in187,
    in186,
    in185,
    in184,
    in183,
    in182,
    in181,
    in180,
    in179,
    in178,
    in177,
    in176,
    in175,
    in174,
    in173,
    in172,
    in171,
    in170,
    in169,
    in168,
    in167,
    in166,
    in165,
    in164,
    in163,
    in162,
    in161,
    in160,
    in159,
    in158,
    in157,
    in156,
    in155,
    in154,
    in153,
    in152,
    in151,
    in150,
    in149,
    in148,
    in147,
    in146,
    in145,
    in144,
    in143,
    in142,
    in141,
    in140,
    in139,
    in138,
    in137,
    in136,
    in135,
    in134,
    in133,
    in132,
    in131,
    in130,
    in129,
    in128,
    in127,
    in126,
    in125,
    in124,
    in123,
    in122,
    in121,
    in120,
    in119,
    in118,
    in117,
    in116,
    in115,
    in114,
    in113,
    in112,
    in111,
    in110,
    in109,
    in108,
    in107,
    in106,
    in105,
    in104,
    in103,
    in102,
    in101,
    in100,
    in99,
    in98,
    in97,
    in96,
    in95,
    in94,
    in93,
    in92,
    in91,
    in90,
    in89,
    in88,
    in87,
    in86,
    in85,
    in84,
    in83,
    in82,
    in81,
    in80,
    in79,
    in78,
    in77,
    in76,
    in75,
    in74,
    in73,
    in72,
    in71,
    in70,
    in69,
    in68,
    in67,
    in66,
    in65,
    in64,
    in63,
    in62,
    in61,
    in60,
    in59,
    in58,
    in57,
    in56,
    in55,
    in54,
    in53,
    in52,
    in51,
    in50,
    in49,
    in48,
    in47,
    in46,
    in45,
    in44,
    in43,
    in42,
    in41,
    in40,
    in39,
    in38,
    in37,
    in36,
    in35,
    in34,
    in33,
    in32,
    in31,
    in30,
    in29,
    in28,
    in27,
    in26,
    in25,
    in24,
    in23,
    in22,
    in21,
    in20,
    in19,
    in18,
    in17,
    in16,
    in15,
    in14,
    in13,
    in12,
    in11,
    in10,
    in9,
    in8,
    in7,
    in6,
    in5,
    in4,
    in3,
    in2,
    in1,
    in0,
    out15_15,
    out15_14,
    out15_13,
    out15_12,
    out15_11,
    out15_10,
    out15_9,
    out15_8,
    out15_7,
    out15_6,
    out15_5,
    out15_4,
    out15_3,
    out15_2,
    out15_1,
    out15_0,
    out14_15,
    out14_14,
    out14_13,
    out14_12,
    out14_11,
    out14_10,
    out14_9,
    out14_8,
    out14_7,
    out14_6,
    out14_5,
    out14_4,
    out14_3,
    out14_2,
    out14_1,
    out14_0,
    out13_15,
    out13_14,
    out13_13,
    out13_12,
    out13_11,
    out13_10,
    out13_9,
    out13_8,
    out13_7,
    out13_6,
    out13_5,
    out13_4,
    out13_3,
    out13_2,
    out13_1,
    out13_0,
    out12_15,
    out12_14,
    out12_13,
    out12_12,
    out12_11,
    out12_10,
    out12_9,
    out12_8,
    out12_7,
    out12_6,
    out12_5,
    out12_4,
    out12_3,
    out12_2,
    out12_1,
    out12_0,
    out11_15,
    out11_14,
    out11_13,
    out11_12,
    out11_11,
    out11_10,
    out11_9,
    out11_8,
    out11_7,
    out11_6,
    out11_5,
    out11_4,
    out11_3,
    out11_2,
    out11_1,
    out11_0,
    out10_15,
    out10_14,
    out10_13,
    out10_12,
    out10_11,
    out10_10,
    out10_9,
    out10_8,
    out10_7,
    out10_6,
    out10_5,
    out10_4,
    out10_3,
    out10_2,
    out10_1,
    out10_0,
    out9_15,
    out9_14,
    out9_13,
    out9_12,
    out9_11,
    out9_10,
    out9_9,
    out9_8,
    out9_7,
    out9_6,
    out9_5,
    out9_4,
    out9_3,
    out9_2,
    out9_1,
    out9_0,
    out8_15,
    out8_14,
    out8_13,
    out8_12,
    out8_11,
    out8_10,
    out8_9,
    out8_8,
    out8_7,
    out8_6,
    out8_5,
    out8_4,
    out8_3,
    out8_2,
    out8_1,
    out8_0,
    out7_15,
    out7_14,
    out7_13,
    out7_12,
    out7_11,
    out7_10,
    out7_9,
    out7_8,
    out7_7,
    out7_6,
    out7_5,
    out7_4,
    out7_3,
    out7_2,
    out7_1,
    out7_0,
    out6_15,
    out6_14,
    out6_13,
    out6_12,
    out6_11,
    out6_10,
    out6_9,
    out6_8,
    out6_7,
    out6_6,
    out6_5,
    out6_4,
    out6_3,
    out6_2,
    out6_1,
    out6_0,
    out5_15,
    out5_14,
    out5_13,
    out5_12,
    out5_11,
    out5_10,
    out5_9,
    out5_8,
    out5_7,
    out5_6,
    out5_5,
    out5_4,
    out5_3,
    out5_2,
    out5_1,
    out5_0,
    out4_15,
    out4_14,
    out4_13,
    out4_12,
    out4_11,
    out4_10,
    out4_9,
    out4_8,
    out4_7,
    out4_6,
    out4_5,
    out4_4,
    out4_3,
    out4_2,
    out4_1,
    out4_0,
    out3_15,
    out3_14,
    out3_13,
    out3_12,
    out3_11,
    out3_10,
    out3_9,
    out3_8,
    out3_7,
    out3_6,
    out3_5,
    out3_4,
    out3_3,
    out3_2,
    out3_1,
    out3_0,
    out2_15,
    out2_14,
    out2_13,
    out2_12,
    out2_11,
    out2_10,
    out2_9,
    out2_8,
    out2_7,
    out2_6,
    out2_5,
    out2_4,
    out2_3,
    out2_2,
    out2_1,
    out2_0,
    out1_15,
    out1_14,
    out1_13,
    out1_12,
    out1_11,
    out1_10,
    out1_9,
    out1_8,
    out1_7,
    out1_6,
    out1_5,
    out1_4,
    out1_3,
    out1_2,
    out1_1,
    out1_0,
    out0_15,
    out0_14,
    out0_13,
    out0_12,
    out0_11,
    out0_10,
    out0_9,
    out0_8,
    out0_7,
    out0_6,
    out0_5,
    out0_4,
    out0_3,
    out0_2,
    out0_1,
    out0_0
);
    input in255, in254, in253, in252, in251, in250, in249, in248, in247, in246, in245, in244, in243, in242, in241, in240, in239, in238, in237, in236, in235, in234, in233, in232, in231, in230, in229, in228, in227, in226, in225, in224, in223, in222, in221, in220, in219, in218, in217, in216, in215, in214, in213, in212, in211, in210, in209, in208, in207, in206, in205, in204, in203, in202, in201, in200, in199, in198, in197, in196, in195, in194, in193, in192, in191, in190, in189, in188, in187, in186, in185, in184, in183, in182, in181, in180, in179, in178, in177, in176, in175, in174, in173, in172, in171, in170, in169, in168, in167, in166, in165, in164, in163, in162, in161, in160, in159, in158, in157, in156, in155, in154, in153, in152, in151, in150, in149, in148, in147, in146, in145, in144, in143, in142, in141, in140, in139, in138, in137, in136, in135, in134, in133, in132, in131, in130, in129, in128, in127, in126, in125, in124, in123, in122, in121, in120, in119, in118, in117, in116, in115, in114, in113, in112, in111, in110, in109, in108, in107, in106, in105, in104, in103, in102, in101, in100, in99, in98, in97, in96, in95, in94, in93, in92, in91, in90, in89, in88, in87, in86, in85, in84, in83, in82, in81, in80, in79, in78, in77, in76, in75, in74, in73, in72, in71, in70, in69, in68, in67, in66, in65, in64, in63, in62, in61, in60, in59, in58, in57, in56, in55, in54, in53, in52, in51, in50, in49, in48, in47, in46, in45, in44, in43, in42, in41, in40, in39, in38, in37, in36, in35, in34, in33, in32, in31, in30, in29, in28, in27, in26, in25, in24, in23, in22, in21, in20, in19, in18, in17, in16, in15, in14, in13, in12, in11, in10, in9, in8, in7, in6, in5, in4, in3, in2, in1, in0;
    output out15_15, out15_14, out15_13, out15_12, out15_11, out15_10, out15_9, out15_8, out15_7, out15_6, out15_5, out15_4, out15_3, out15_2, out15_1, out15_0, out14_15, out14_14, out14_13, out14_12, out14_11, out14_10, out14_9, out14_8, out14_7, out14_6, out14_5, out14_4, out14_3, out14_2, out14_1, out14_0, out13_15, out13_14, out13_13, out13_12, out13_11, out13_10, out13_9, out13_8, out13_7, out13_6, out13_5, out13_4, out13_3, out13_2, out13_1, out13_0, out12_15, out12_14, out12_13, out12_12, out12_11, out12_10, out12_9, out12_8, out12_7, out12_6, out12_5, out12_4, out12_3, out12_2, out12_1, out12_0, out11_15, out11_14, out11_13, out11_12, out11_11, out11_10, out11_9, out11_8, out11_7, out11_6, out11_5, out11_4, out11_3, out11_2, out11_1, out11_0, out10_15, out10_14, out10_13, out10_12, out10_11, out10_10, out10_9, out10_8, out10_7, out10_6, out10_5, out10_4, out10_3, out10_2, out10_1, out10_0, out9_15, out9_14, out9_13, out9_12, out9_11, out9_10, out9_9, out9_8, out9_7, out9_6, out9_5, out9_4, out9_3, out9_2, out9_1, out9_0, out8_15, out8_14, out8_13, out8_12, out8_11, out8_10, out8_9, out8_8, out8_7, out8_6, out8_5, out8_4, out8_3, out8_2, out8_1, out8_0, out7_15, out7_14, out7_13, out7_12, out7_11, out7_10, out7_9, out7_8, out7_7, out7_6, out7_5, out7_4, out7_3, out7_2, out7_1, out7_0, out6_15, out6_14, out6_13, out6_12, out6_11, out6_10, out6_9, out6_8, out6_7, out6_6, out6_5, out6_4, out6_3, out6_2, out6_1, out6_0, out5_15, out5_14, out5_13, out5_12, out5_11, out5_10, out5_9, out5_8, out5_7, out5_6, out5_5, out5_4, out5_3, out5_2, out5_1, out5_0, out4_15, out4_14, out4_13, out4_12, out4_11, out4_10, out4_9, out4_8, out4_7, out4_6, out4_5, out4_4, out4_3, out4_2, out4_1, out4_0, out3_15, out3_14, out3_13, out3_12, out3_11, out3_10, out3_9, out3_8, out3_7, out3_6, out3_5, out3_4, out3_3, out3_2, out3_1, out3_0, out2_15, out2_14, out2_13, out2_12, out2_11, out2_10, out2_9, out2_8, out2_7, out2_6, out2_5, out2_4, out2_3, out2_2, out2_1, out2_0, out1_15, out1_14, out1_13, out1_12, out1_11, out1_10, out1_9, out1_8, out1_7, out1_6, out1_5, out1_4, out1_3, out1_2, out1_1, out1_0, out0_15, out0_14, out0_13, out0_12, out0_11, out0_10, out0_9, out0_8, out0_7, out0_6, out0_5, out0_4, out0_3, out0_2, out0_1, out0_0;
    electrical in255, in254, in253, in252, in251, in250, in249, in248, in247, in246, in245, in244, in243, in242, in241, in240, in239, in238, in237, in236, in235, in234, in233, in232, in231, in230, in229, in228, in227, in226, in225, in224, in223, in222, in221, in220, in219, in218, in217, in216, in215, in214, in213, in212, in211, in210, in209, in208, in207, in206, in205, in204, in203, in202, in201, in200, in199, in198, in197, in196, in195, in194, in193, in192, in191, in190, in189, in188, in187, in186, in185, in184, in183, in182, in181, in180, in179, in178, in177, in176, in175, in174, in173, in172, in171, in170, in169, in168, in167, in166, in165, in164, in163, in162, in161, in160, in159, in158, in157, in156, in155, in154, in153, in152, in151, in150, in149, in148, in147, in146, in145, in144, in143, in142, in141, in140, in139, in138, in137, in136, in135, in134, in133, in132, in131, in130, in129, in128, in127, in126, in125, in124, in123, in122, in121, in120, in119, in118, in117, in116, in115, in114, in113, in112, in111, in110, in109, in108, in107, in106, in105, in104, in103, in102, in101, in100, in99, in98, in97, in96, in95, in94, in93, in92, in91, in90, in89, in88, in87, in86, in85, in84, in83, in82, in81, in80, in79, in78, in77, in76, in75, in74, in73, in72, in71, in70, in69, in68, in67, in66, in65, in64, in63, in62, in61, in60, in59, in58, in57, in56, in55, in54, in53, in52, in51, in50, in49, in48, in47, in46, in45, in44, in43, in42, in41, in40, in39, in38, in37, in36, in35, in34, in33, in32, in31, in30, in29, in28, in27, in26, in25, in24, in23, in22, in21, in20, in19, in18, in17, in16, in15, in14, in13, in12, in11, in10, in9, in8, in7, in6, in5, in4, in3, in2, in1, in0, out15_15, out15_14, out15_13, out15_12, out15_11, out15_10, out15_9, out15_8, out15_7, out15_6, out15_5, out15_4, out15_3, out15_2, out15_1, out15_0, out14_15, out14_14, out14_13, out14_12, out14_11, out14_10, out14_9, out14_8, out14_7, out14_6, out14_5, out14_4, out14_3, out14_2, out14_1, out14_0, out13_15, out13_14, out13_13, out13_12, out13_11, out13_10, out13_9, out13_8, out13_7, out13_6, out13_5, out13_4, out13_3, out13_2, out13_1, out13_0, out12_15, out12_14, out12_13, out12_12, out12_11, out12_10, out12_9, out12_8, out12_7, out12_6, out12_5, out12_4, out12_3, out12_2, out12_1, out12_0, out11_15, out11_14, out11_13, out11_12, out11_11, out11_10, out11_9, out11_8, out11_7, out11_6, out11_5, out11_4, out11_3, out11_2, out11_1, out11_0, out10_15, out10_14, out10_13, out10_12, out10_11, out10_10, out10_9, out10_8, out10_7, out10_6, out10_5, out10_4, out10_3, out10_2, out10_1, out10_0, out9_15, out9_14, out9_13, out9_12, out9_11, out9_10, out9_9, out9_8, out9_7, out9_6, out9_5, out9_4, out9_3, out9_2, out9_1, out9_0, out8_15, out8_14, out8_13, out8_12, out8_11, out8_10, out8_9, out8_8, out8_7, out8_6, out8_5, out8_4, out8_3, out8_2, out8_1, out8_0, out7_15, out7_14, out7_13, out7_12, out7_11, out7_10, out7_9, out7_8, out7_7, out7_6, out7_5, out7_4, out7_3, out7_2, out7_1, out7_0, out6_15, out6_14, out6_13, out6_12, out6_11, out6_10, out6_9, out6_8, out6_7, out6_6, out6_5, out6_4, out6_3, out6_2, out6_1, out6_0, out5_15, out5_14, out5_13, out5_12, out5_11, out5_10, out5_9, out5_8, out5_7, out5_6, out5_5, out5_4, out5_3, out5_2, out5_1, out5_0, out4_15, out4_14, out4_13, out4_12, out4_11, out4_10, out4_9, out4_8, out4_7, out4_6, out4_5, out4_4, out4_3, out4_2, out4_1, out4_0, out3_15, out3_14, out3_13, out3_12, out3_11, out3_10, out3_9, out3_8, out3_7, out3_6, out3_5, out3_4, out3_3, out3_2, out3_1, out3_0, out2_15, out2_14, out2_13, out2_12, out2_11, out2_10, out2_9, out2_8, out2_7, out2_6, out2_5, out2_4, out2_3, out2_2, out2_1, out2_0, out1_15, out1_14, out1_13, out1_12, out1_11, out1_10, out1_9, out1_8, out1_7, out1_6, out1_5, out1_4, out1_3, out1_2, out1_1, out1_0, out0_15, out0_14, out0_13, out0_12, out0_11, out0_10, out0_9, out0_8, out0_7, out0_6, out0_5, out0_4, out0_3, out0_2, out0_1, out0_0;
    parameter real vdd = 0.9;
    parameter real vth = 0.45;
    parameter real tr = 20p;
    analog begin
        V(out0_0) <+ transition((V(in0) > vth) ? vdd : 0.0, 0, tr, tr);
        V(out0_1) <+ transition((V(in1) > vth) ? vdd : 0.0, 0, tr, tr);
        V(out0_2) <+ transition((V(in2) > vth) ? vdd : 0.0, 0, tr, tr);
        V(out0_3) <+ transition((V(in3) > vth) ? vdd : 0.0, 0, tr, tr);
        V(out0_4) <+ transition((V(in4) > vth) ? vdd : 0.0, 0, tr, tr);
        V(out0_5) <+ transition((V(in5) > vth) ? vdd : 0.0, 0, tr, tr);
        V(out0_6) <+ transition((V(in6) > vth) ? vdd : 0.0, 0, tr, tr);
        V(out0_7) <+ transition((V(in7) > vth) ? vdd : 0.0, 0, tr, tr);
        V(out0_8) <+ transition((V(in8) > vth) ? vdd : 0.0, 0, tr, tr);
        V(out0_9) <+ transition((V(in9) > vth) ? vdd : 0.0, 0, tr, tr);
        V(out0_10) <+ transition((V(in10) > vth) ? vdd : 0.0, 0, tr, tr);
        V(out0_11) <+ transition((V(in11) > vth) ? vdd : 0.0, 0, tr, tr);
        V(out0_12) <+ transition((V(in12) > vth) ? vdd : 0.0, 0, tr, tr);
        V(out0_13) <+ transition((V(in13) > vth) ? vdd : 0.0, 0, tr, tr);
        V(out0_14) <+ transition((V(in14) > vth) ? vdd : 0.0, 0, tr, tr);
        V(out0_15) <+ transition((V(in15) > vth) ? vdd : 0.0, 0, tr, tr);
        V(out1_0) <+ transition((V(in16) > vth) ? vdd : 0.0, 0, tr, tr);
        V(out1_1) <+ transition((V(in17) > vth) ? vdd : 0.0, 0, tr, tr);
        V(out1_2) <+ transition((V(in18) > vth) ? vdd : 0.0, 0, tr, tr);
        V(out1_3) <+ transition((V(in19) > vth) ? vdd : 0.0, 0, tr, tr);
        V(out1_4) <+ transition((V(in20) > vth) ? vdd : 0.0, 0, tr, tr);
        V(out1_5) <+ transition((V(in21) > vth) ? vdd : 0.0, 0, tr, tr);
        V(out1_6) <+ transition((V(in22) > vth) ? vdd : 0.0, 0, tr, tr);
        V(out1_7) <+ transition((V(in23) > vth) ? vdd : 0.0, 0, tr, tr);
        V(out1_8) <+ transition((V(in24) > vth) ? vdd : 0.0, 0, tr, tr);
        V(out1_9) <+ transition((V(in25) > vth) ? vdd : 0.0, 0, tr, tr);
        V(out1_10) <+ transition((V(in26) > vth) ? vdd : 0.0, 0, tr, tr);
        V(out1_11) <+ transition((V(in27) > vth) ? vdd : 0.0, 0, tr, tr);
        V(out1_12) <+ transition((V(in28) > vth) ? vdd : 0.0, 0, tr, tr);
        V(out1_13) <+ transition((V(in29) > vth) ? vdd : 0.0, 0, tr, tr);
        V(out1_14) <+ transition((V(in30) > vth) ? vdd : 0.0, 0, tr, tr);
        V(out1_15) <+ transition((V(in31) > vth) ? vdd : 0.0, 0, tr, tr);
        V(out2_0) <+ transition((V(in32) > vth) ? vdd : 0.0, 0, tr, tr);
        V(out2_1) <+ transition((V(in33) > vth) ? vdd : 0.0, 0, tr, tr);
        V(out2_2) <+ transition((V(in34) > vth) ? vdd : 0.0, 0, tr, tr);
        V(out2_3) <+ transition((V(in35) > vth) ? vdd : 0.0, 0, tr, tr);
        V(out2_4) <+ transition((V(in36) > vth) ? vdd : 0.0, 0, tr, tr);
        V(out2_5) <+ transition((V(in37) > vth) ? vdd : 0.0, 0, tr, tr);
        V(out2_6) <+ transition((V(in38) > vth) ? vdd : 0.0, 0, tr, tr);
        V(out2_7) <+ transition((V(in39) > vth) ? vdd : 0.0, 0, tr, tr);
        V(out2_8) <+ transition((V(in40) > vth) ? vdd : 0.0, 0, tr, tr);
        V(out2_9) <+ transition((V(in41) > vth) ? vdd : 0.0, 0, tr, tr);
        V(out2_10) <+ transition((V(in42) > vth) ? vdd : 0.0, 0, tr, tr);
        V(out2_11) <+ transition((V(in43) > vth) ? vdd : 0.0, 0, tr, tr);
        V(out2_12) <+ transition((V(in44) > vth) ? vdd : 0.0, 0, tr, tr);
        V(out2_13) <+ transition((V(in45) > vth) ? vdd : 0.0, 0, tr, tr);
        V(out2_14) <+ transition((V(in46) > vth) ? vdd : 0.0, 0, tr, tr);
        V(out2_15) <+ transition((V(in47) > vth) ? vdd : 0.0, 0, tr, tr);
        V(out3_0) <+ transition((V(in48) > vth) ? vdd : 0.0, 0, tr, tr);
        V(out3_1) <+ transition((V(in49) > vth) ? vdd : 0.0, 0, tr, tr);
        V(out3_2) <+ transition((V(in50) > vth) ? vdd : 0.0, 0, tr, tr);
        V(out3_3) <+ transition((V(in51) > vth) ? vdd : 0.0, 0, tr, tr);
        V(out3_4) <+ transition((V(in52) > vth) ? vdd : 0.0, 0, tr, tr);
        V(out3_5) <+ transition((V(in53) > vth) ? vdd : 0.0, 0, tr, tr);
        V(out3_6) <+ transition((V(in54) > vth) ? vdd : 0.0, 0, tr, tr);
        V(out3_7) <+ transition((V(in55) > vth) ? vdd : 0.0, 0, tr, tr);
        V(out3_8) <+ transition((V(in56) > vth) ? vdd : 0.0, 0, tr, tr);
        V(out3_9) <+ transition((V(in57) > vth) ? vdd : 0.0, 0, tr, tr);
        V(out3_10) <+ transition((V(in58) > vth) ? vdd : 0.0, 0, tr, tr);
        V(out3_11) <+ transition((V(in59) > vth) ? vdd : 0.0, 0, tr, tr);
        V(out3_12) <+ transition((V(in60) > vth) ? vdd : 0.0, 0, tr, tr);
        V(out3_13) <+ transition((V(in61) > vth) ? vdd : 0.0, 0, tr, tr);
        V(out3_14) <+ transition((V(in62) > vth) ? vdd : 0.0, 0, tr, tr);
        V(out3_15) <+ transition((V(in63) > vth) ? vdd : 0.0, 0, tr, tr);
        V(out4_0) <+ transition((V(in64) > vth) ? vdd : 0.0, 0, tr, tr);
        V(out4_1) <+ transition((V(in65) > vth) ? vdd : 0.0, 0, tr, tr);
        V(out4_2) <+ transition((V(in66) > vth) ? vdd : 0.0, 0, tr, tr);
        V(out4_3) <+ transition((V(in67) > vth) ? vdd : 0.0, 0, tr, tr);
        V(out4_4) <+ transition((V(in68) > vth) ? vdd : 0.0, 0, tr, tr);
        V(out4_5) <+ transition((V(in69) > vth) ? vdd : 0.0, 0, tr, tr);
        V(out4_6) <+ transition((V(in70) > vth) ? vdd : 0.0, 0, tr, tr);
        V(out4_7) <+ transition((V(in71) > vth) ? vdd : 0.0, 0, tr, tr);
        V(out4_8) <+ transition((V(in72) > vth) ? vdd : 0.0, 0, tr, tr);
        V(out4_9) <+ transition((V(in73) > vth) ? vdd : 0.0, 0, tr, tr);
        V(out4_10) <+ transition((V(in74) > vth) ? vdd : 0.0, 0, tr, tr);
        V(out4_11) <+ transition((V(in75) > vth) ? vdd : 0.0, 0, tr, tr);
        V(out4_12) <+ transition((V(in76) > vth) ? vdd : 0.0, 0, tr, tr);
        V(out4_13) <+ transition((V(in77) > vth) ? vdd : 0.0, 0, tr, tr);
        V(out4_14) <+ transition((V(in78) > vth) ? vdd : 0.0, 0, tr, tr);
        V(out4_15) <+ transition((V(in79) > vth) ? vdd : 0.0, 0, tr, tr);
        V(out5_0) <+ transition((V(in80) > vth) ? vdd : 0.0, 0, tr, tr);
        V(out5_1) <+ transition((V(in81) > vth) ? vdd : 0.0, 0, tr, tr);
        V(out5_2) <+ transition((V(in82) > vth) ? vdd : 0.0, 0, tr, tr);
        V(out5_3) <+ transition((V(in83) > vth) ? vdd : 0.0, 0, tr, tr);
        V(out5_4) <+ transition((V(in84) > vth) ? vdd : 0.0, 0, tr, tr);
        V(out5_5) <+ transition((V(in85) > vth) ? vdd : 0.0, 0, tr, tr);
        V(out5_6) <+ transition((V(in86) > vth) ? vdd : 0.0, 0, tr, tr);
        V(out5_7) <+ transition((V(in87) > vth) ? vdd : 0.0, 0, tr, tr);
        V(out5_8) <+ transition((V(in88) > vth) ? vdd : 0.0, 0, tr, tr);
        V(out5_9) <+ transition((V(in89) > vth) ? vdd : 0.0, 0, tr, tr);
        V(out5_10) <+ transition((V(in90) > vth) ? vdd : 0.0, 0, tr, tr);
        V(out5_11) <+ transition((V(in91) > vth) ? vdd : 0.0, 0, tr, tr);
        V(out5_12) <+ transition((V(in92) > vth) ? vdd : 0.0, 0, tr, tr);
        V(out5_13) <+ transition((V(in93) > vth) ? vdd : 0.0, 0, tr, tr);
        V(out5_14) <+ transition((V(in94) > vth) ? vdd : 0.0, 0, tr, tr);
        V(out5_15) <+ transition((V(in95) > vth) ? vdd : 0.0, 0, tr, tr);
        V(out6_0) <+ transition((V(in96) > vth) ? vdd : 0.0, 0, tr, tr);
        V(out6_1) <+ transition((V(in97) > vth) ? vdd : 0.0, 0, tr, tr);
        V(out6_2) <+ transition((V(in98) > vth) ? vdd : 0.0, 0, tr, tr);
        V(out6_3) <+ transition((V(in99) > vth) ? vdd : 0.0, 0, tr, tr);
        V(out6_4) <+ transition((V(in100) > vth) ? vdd : 0.0, 0, tr, tr);
        V(out6_5) <+ transition((V(in101) > vth) ? vdd : 0.0, 0, tr, tr);
        V(out6_6) <+ transition((V(in102) > vth) ? vdd : 0.0, 0, tr, tr);
        V(out6_7) <+ transition((V(in103) > vth) ? vdd : 0.0, 0, tr, tr);
        V(out6_8) <+ transition((V(in104) > vth) ? vdd : 0.0, 0, tr, tr);
        V(out6_9) <+ transition((V(in105) > vth) ? vdd : 0.0, 0, tr, tr);
        V(out6_10) <+ transition((V(in106) > vth) ? vdd : 0.0, 0, tr, tr);
        V(out6_11) <+ transition((V(in107) > vth) ? vdd : 0.0, 0, tr, tr);
        V(out6_12) <+ transition((V(in108) > vth) ? vdd : 0.0, 0, tr, tr);
        V(out6_13) <+ transition((V(in109) > vth) ? vdd : 0.0, 0, tr, tr);
        V(out6_14) <+ transition((V(in110) > vth) ? vdd : 0.0, 0, tr, tr);
        V(out6_15) <+ transition((V(in111) > vth) ? vdd : 0.0, 0, tr, tr);
        V(out7_0) <+ transition((V(in112) > vth) ? vdd : 0.0, 0, tr, tr);
        V(out7_1) <+ transition((V(in113) > vth) ? vdd : 0.0, 0, tr, tr);
        V(out7_2) <+ transition((V(in114) > vth) ? vdd : 0.0, 0, tr, tr);
        V(out7_3) <+ transition((V(in115) > vth) ? vdd : 0.0, 0, tr, tr);
        V(out7_4) <+ transition((V(in116) > vth) ? vdd : 0.0, 0, tr, tr);
        V(out7_5) <+ transition((V(in117) > vth) ? vdd : 0.0, 0, tr, tr);
        V(out7_6) <+ transition((V(in118) > vth) ? vdd : 0.0, 0, tr, tr);
        V(out7_7) <+ transition((V(in119) > vth) ? vdd : 0.0, 0, tr, tr);
        V(out7_8) <+ transition((V(in120) > vth) ? vdd : 0.0, 0, tr, tr);
        V(out7_9) <+ transition((V(in121) > vth) ? vdd : 0.0, 0, tr, tr);
        V(out7_10) <+ transition((V(in122) > vth) ? vdd : 0.0, 0, tr, tr);
        V(out7_11) <+ transition((V(in123) > vth) ? vdd : 0.0, 0, tr, tr);
        V(out7_12) <+ transition((V(in124) > vth) ? vdd : 0.0, 0, tr, tr);
        V(out7_13) <+ transition((V(in125) > vth) ? vdd : 0.0, 0, tr, tr);
        V(out7_14) <+ transition((V(in126) > vth) ? vdd : 0.0, 0, tr, tr);
        V(out7_15) <+ transition((V(in127) > vth) ? vdd : 0.0, 0, tr, tr);
        V(out8_0) <+ transition((V(in128) > vth) ? vdd : 0.0, 0, tr, tr);
        V(out8_1) <+ transition((V(in129) > vth) ? vdd : 0.0, 0, tr, tr);
        V(out8_2) <+ transition((V(in130) > vth) ? vdd : 0.0, 0, tr, tr);
        V(out8_3) <+ transition((V(in131) > vth) ? vdd : 0.0, 0, tr, tr);
        V(out8_4) <+ transition((V(in132) > vth) ? vdd : 0.0, 0, tr, tr);
        V(out8_5) <+ transition((V(in133) > vth) ? vdd : 0.0, 0, tr, tr);
        V(out8_6) <+ transition((V(in134) > vth) ? vdd : 0.0, 0, tr, tr);
        V(out8_7) <+ transition((V(in135) > vth) ? vdd : 0.0, 0, tr, tr);
        V(out8_8) <+ transition((V(in136) > vth) ? vdd : 0.0, 0, tr, tr);
        V(out8_9) <+ transition((V(in137) > vth) ? vdd : 0.0, 0, tr, tr);
        V(out8_10) <+ transition((V(in138) > vth) ? vdd : 0.0, 0, tr, tr);
        V(out8_11) <+ transition((V(in139) > vth) ? vdd : 0.0, 0, tr, tr);
        V(out8_12) <+ transition((V(in140) > vth) ? vdd : 0.0, 0, tr, tr);
        V(out8_13) <+ transition((V(in141) > vth) ? vdd : 0.0, 0, tr, tr);
        V(out8_14) <+ transition((V(in142) > vth) ? vdd : 0.0, 0, tr, tr);
        V(out8_15) <+ transition((V(in143) > vth) ? vdd : 0.0, 0, tr, tr);
        V(out9_0) <+ transition((V(in144) > vth) ? vdd : 0.0, 0, tr, tr);
        V(out9_1) <+ transition((V(in145) > vth) ? vdd : 0.0, 0, tr, tr);
        V(out9_2) <+ transition((V(in146) > vth) ? vdd : 0.0, 0, tr, tr);
        V(out9_3) <+ transition((V(in147) > vth) ? vdd : 0.0, 0, tr, tr);
        V(out9_4) <+ transition((V(in148) > vth) ? vdd : 0.0, 0, tr, tr);
        V(out9_5) <+ transition((V(in149) > vth) ? vdd : 0.0, 0, tr, tr);
        V(out9_6) <+ transition((V(in150) > vth) ? vdd : 0.0, 0, tr, tr);
        V(out9_7) <+ transition((V(in151) > vth) ? vdd : 0.0, 0, tr, tr);
        V(out9_8) <+ transition((V(in152) > vth) ? vdd : 0.0, 0, tr, tr);
        V(out9_9) <+ transition((V(in153) > vth) ? vdd : 0.0, 0, tr, tr);
        V(out9_10) <+ transition((V(in154) > vth) ? vdd : 0.0, 0, tr, tr);
        V(out9_11) <+ transition((V(in155) > vth) ? vdd : 0.0, 0, tr, tr);
        V(out9_12) <+ transition((V(in156) > vth) ? vdd : 0.0, 0, tr, tr);
        V(out9_13) <+ transition((V(in157) > vth) ? vdd : 0.0, 0, tr, tr);
        V(out9_14) <+ transition((V(in158) > vth) ? vdd : 0.0, 0, tr, tr);
        V(out9_15) <+ transition((V(in159) > vth) ? vdd : 0.0, 0, tr, tr);
        V(out10_0) <+ transition((V(in160) > vth) ? vdd : 0.0, 0, tr, tr);
        V(out10_1) <+ transition((V(in161) > vth) ? vdd : 0.0, 0, tr, tr);
        V(out10_2) <+ transition((V(in162) > vth) ? vdd : 0.0, 0, tr, tr);
        V(out10_3) <+ transition((V(in163) > vth) ? vdd : 0.0, 0, tr, tr);
        V(out10_4) <+ transition((V(in164) > vth) ? vdd : 0.0, 0, tr, tr);
        V(out10_5) <+ transition((V(in165) > vth) ? vdd : 0.0, 0, tr, tr);
        V(out10_6) <+ transition((V(in166) > vth) ? vdd : 0.0, 0, tr, tr);
        V(out10_7) <+ transition((V(in167) > vth) ? vdd : 0.0, 0, tr, tr);
        V(out10_8) <+ transition((V(in168) > vth) ? vdd : 0.0, 0, tr, tr);
        V(out10_9) <+ transition((V(in169) > vth) ? vdd : 0.0, 0, tr, tr);
        V(out10_10) <+ transition((V(in170) > vth) ? vdd : 0.0, 0, tr, tr);
        V(out10_11) <+ transition((V(in171) > vth) ? vdd : 0.0, 0, tr, tr);
        V(out10_12) <+ transition((V(in172) > vth) ? vdd : 0.0, 0, tr, tr);
        V(out10_13) <+ transition((V(in173) > vth) ? vdd : 0.0, 0, tr, tr);
        V(out10_14) <+ transition((V(in174) > vth) ? vdd : 0.0, 0, tr, tr);
        V(out10_15) <+ transition((V(in175) > vth) ? vdd : 0.0, 0, tr, tr);
        V(out11_0) <+ transition((V(in176) > vth) ? vdd : 0.0, 0, tr, tr);
        V(out11_1) <+ transition((V(in177) > vth) ? vdd : 0.0, 0, tr, tr);
        V(out11_2) <+ transition((V(in178) > vth) ? vdd : 0.0, 0, tr, tr);
        V(out11_3) <+ transition((V(in179) > vth) ? vdd : 0.0, 0, tr, tr);
        V(out11_4) <+ transition((V(in180) > vth) ? vdd : 0.0, 0, tr, tr);
        V(out11_5) <+ transition((V(in181) > vth) ? vdd : 0.0, 0, tr, tr);
        V(out11_6) <+ transition((V(in182) > vth) ? vdd : 0.0, 0, tr, tr);
        V(out11_7) <+ transition((V(in183) > vth) ? vdd : 0.0, 0, tr, tr);
        V(out11_8) <+ transition((V(in184) > vth) ? vdd : 0.0, 0, tr, tr);
        V(out11_9) <+ transition((V(in185) > vth) ? vdd : 0.0, 0, tr, tr);
        V(out11_10) <+ transition((V(in186) > vth) ? vdd : 0.0, 0, tr, tr);
        V(out11_11) <+ transition((V(in187) > vth) ? vdd : 0.0, 0, tr, tr);
        V(out11_12) <+ transition((V(in188) > vth) ? vdd : 0.0, 0, tr, tr);
        V(out11_13) <+ transition((V(in189) > vth) ? vdd : 0.0, 0, tr, tr);
        V(out11_14) <+ transition((V(in190) > vth) ? vdd : 0.0, 0, tr, tr);
        V(out11_15) <+ transition((V(in191) > vth) ? vdd : 0.0, 0, tr, tr);
        V(out12_0) <+ transition((V(in192) > vth) ? vdd : 0.0, 0, tr, tr);
        V(out12_1) <+ transition((V(in193) > vth) ? vdd : 0.0, 0, tr, tr);
        V(out12_2) <+ transition((V(in194) > vth) ? vdd : 0.0, 0, tr, tr);
        V(out12_3) <+ transition((V(in195) > vth) ? vdd : 0.0, 0, tr, tr);
        V(out12_4) <+ transition((V(in196) > vth) ? vdd : 0.0, 0, tr, tr);
        V(out12_5) <+ transition((V(in197) > vth) ? vdd : 0.0, 0, tr, tr);
        V(out12_6) <+ transition((V(in198) > vth) ? vdd : 0.0, 0, tr, tr);
        V(out12_7) <+ transition((V(in199) > vth) ? vdd : 0.0, 0, tr, tr);
        V(out12_8) <+ transition((V(in200) > vth) ? vdd : 0.0, 0, tr, tr);
        V(out12_9) <+ transition((V(in201) > vth) ? vdd : 0.0, 0, tr, tr);
        V(out12_10) <+ transition((V(in202) > vth) ? vdd : 0.0, 0, tr, tr);
        V(out12_11) <+ transition((V(in203) > vth) ? vdd : 0.0, 0, tr, tr);
        V(out12_12) <+ transition((V(in204) > vth) ? vdd : 0.0, 0, tr, tr);
        V(out12_13) <+ transition((V(in205) > vth) ? vdd : 0.0, 0, tr, tr);
        V(out12_14) <+ transition((V(in206) > vth) ? vdd : 0.0, 0, tr, tr);
        V(out12_15) <+ transition((V(in207) > vth) ? vdd : 0.0, 0, tr, tr);
        V(out13_0) <+ transition((V(in208) > vth) ? vdd : 0.0, 0, tr, tr);
        V(out13_1) <+ transition((V(in209) > vth) ? vdd : 0.0, 0, tr, tr);
        V(out13_2) <+ transition((V(in210) > vth) ? vdd : 0.0, 0, tr, tr);
        V(out13_3) <+ transition((V(in211) > vth) ? vdd : 0.0, 0, tr, tr);
        V(out13_4) <+ transition((V(in212) > vth) ? vdd : 0.0, 0, tr, tr);
        V(out13_5) <+ transition((V(in213) > vth) ? vdd : 0.0, 0, tr, tr);
        V(out13_6) <+ transition((V(in214) > vth) ? vdd : 0.0, 0, tr, tr);
        V(out13_7) <+ transition((V(in215) > vth) ? vdd : 0.0, 0, tr, tr);
        V(out13_8) <+ transition((V(in216) > vth) ? vdd : 0.0, 0, tr, tr);
        V(out13_9) <+ transition((V(in217) > vth) ? vdd : 0.0, 0, tr, tr);
        V(out13_10) <+ transition((V(in218) > vth) ? vdd : 0.0, 0, tr, tr);
        V(out13_11) <+ transition((V(in219) > vth) ? vdd : 0.0, 0, tr, tr);
        V(out13_12) <+ transition((V(in220) > vth) ? vdd : 0.0, 0, tr, tr);
        V(out13_13) <+ transition((V(in221) > vth) ? vdd : 0.0, 0, tr, tr);
        V(out13_14) <+ transition((V(in222) > vth) ? vdd : 0.0, 0, tr, tr);
        V(out13_15) <+ transition((V(in223) > vth) ? vdd : 0.0, 0, tr, tr);
        V(out14_0) <+ transition((V(in224) > vth) ? vdd : 0.0, 0, tr, tr);
        V(out14_1) <+ transition((V(in225) > vth) ? vdd : 0.0, 0, tr, tr);
        V(out14_2) <+ transition((V(in226) > vth) ? vdd : 0.0, 0, tr, tr);
        V(out14_3) <+ transition((V(in227) > vth) ? vdd : 0.0, 0, tr, tr);
        V(out14_4) <+ transition((V(in228) > vth) ? vdd : 0.0, 0, tr, tr);
        V(out14_5) <+ transition((V(in229) > vth) ? vdd : 0.0, 0, tr, tr);
        V(out14_6) <+ transition((V(in230) > vth) ? vdd : 0.0, 0, tr, tr);
        V(out14_7) <+ transition((V(in231) > vth) ? vdd : 0.0, 0, tr, tr);
        V(out14_8) <+ transition((V(in232) > vth) ? vdd : 0.0, 0, tr, tr);
        V(out14_9) <+ transition((V(in233) > vth) ? vdd : 0.0, 0, tr, tr);
        V(out14_10) <+ transition((V(in234) > vth) ? vdd : 0.0, 0, tr, tr);
        V(out14_11) <+ transition((V(in235) > vth) ? vdd : 0.0, 0, tr, tr);
        V(out14_12) <+ transition((V(in236) > vth) ? vdd : 0.0, 0, tr, tr);
        V(out14_13) <+ transition((V(in237) > vth) ? vdd : 0.0, 0, tr, tr);
        V(out14_14) <+ transition((V(in238) > vth) ? vdd : 0.0, 0, tr, tr);
        V(out14_15) <+ transition((V(in239) > vth) ? vdd : 0.0, 0, tr, tr);
        V(out15_0) <+ transition((V(in240) > vth) ? vdd : 0.0, 0, tr, tr);
        V(out15_1) <+ transition((V(in241) > vth) ? vdd : 0.0, 0, tr, tr);
        V(out15_2) <+ transition((V(in242) > vth) ? vdd : 0.0, 0, tr, tr);
        V(out15_3) <+ transition((V(in243) > vth) ? vdd : 0.0, 0, tr, tr);
        V(out15_4) <+ transition((V(in244) > vth) ? vdd : 0.0, 0, tr, tr);
        V(out15_5) <+ transition((V(in245) > vth) ? vdd : 0.0, 0, tr, tr);
        V(out15_6) <+ transition((V(in246) > vth) ? vdd : 0.0, 0, tr, tr);
        V(out15_7) <+ transition((V(in247) > vth) ? vdd : 0.0, 0, tr, tr);
        V(out15_8) <+ transition((V(in248) > vth) ? vdd : 0.0, 0, tr, tr);
        V(out15_9) <+ transition((V(in249) > vth) ? vdd : 0.0, 0, tr, tr);
        V(out15_10) <+ transition((V(in250) > vth) ? vdd : 0.0, 0, tr, tr);
        V(out15_11) <+ transition((V(in251) > vth) ? vdd : 0.0, 0, tr, tr);
        V(out15_12) <+ transition((V(in252) > vth) ? vdd : 0.0, 0, tr, tr);
        V(out15_13) <+ transition((V(in253) > vth) ? vdd : 0.0, 0, tr, tr);
        V(out15_14) <+ transition((V(in254) > vth) ? vdd : 0.0, 0, tr, tr);
        V(out15_15) <+ transition((V(in255) > vth) ? vdd : 0.0, 0, tr, tr);
    end
endmodule
