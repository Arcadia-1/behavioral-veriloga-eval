`include "constants.vams"
`include "disciplines.vams"

module bus_split_256_to_16x16(
    input electrical [255:0] in_bus,
    output electrical [15:0] out15,
    output electrical [15:0] out14,
    output electrical [15:0] out13,
    output electrical [15:0] out12,
    output electrical [15:0] out11,
    output electrical [15:0] out10,
    output electrical [15:0] out9,
    output electrical [15:0] out8,
    output electrical [15:0] out7,
    output electrical [15:0] out6,
    output electrical [15:0] out5,
    output electrical [15:0] out4,
    output electrical [15:0] out3,
    output electrical [15:0] out2,
    output electrical [15:0] out1,
    output electrical [15:0] out0
);
    parameter real vdd = 0.9;
    parameter real vth = 0.45;
    parameter real tr = 20p;

    genvar block;
    genvar bit;

    analog begin
        for (block = 0; block < 16; block = block + 1) begin
            for (bit = 0; bit < 16; bit = bit + 1) begin
                if (block == 0) V(out0[bit]) <+ transition((V(in_bus[16 * block + bit]) > vth) ? vdd : 0.0, 0, tr, tr);
                if (block == 1) V(out1[bit]) <+ transition((V(in_bus[16 * block + bit]) > vth) ? vdd : 0.0, 0, tr, tr);
                if (block == 2) V(out2[bit]) <+ transition((V(in_bus[16 * block + bit]) > vth) ? vdd : 0.0, 0, tr, tr);
                if (block == 3) V(out3[bit]) <+ transition((V(in_bus[16 * block + bit]) > vth) ? vdd : 0.0, 0, tr, tr);
                if (block == 4) V(out4[bit]) <+ transition((V(in_bus[16 * block + bit]) > vth) ? vdd : 0.0, 0, tr, tr);
                if (block == 5) V(out5[bit]) <+ transition((V(in_bus[16 * block + bit]) > vth) ? vdd : 0.0, 0, tr, tr);
                if (block == 6) V(out6[bit]) <+ transition((V(in_bus[16 * block + bit]) > vth) ? vdd : 0.0, 0, tr, tr);
                if (block == 7) V(out7[bit]) <+ transition((V(in_bus[16 * block + bit]) > vth) ? vdd : 0.0, 0, tr, tr);
                if (block == 8) V(out8[bit]) <+ transition((V(in_bus[16 * block + bit]) > vth) ? vdd : 0.0, 0, tr, tr);
                if (block == 9) V(out9[bit]) <+ transition((V(in_bus[16 * block + bit]) > vth) ? vdd : 0.0, 0, tr, tr);
                if (block == 10) V(out10[bit]) <+ transition((V(in_bus[16 * block + bit]) > vth) ? vdd : 0.0, 0, tr, tr);
                if (block == 11) V(out11[bit]) <+ transition((V(in_bus[16 * block + bit]) > vth) ? vdd : 0.0, 0, tr, tr);
                if (block == 12) V(out12[bit]) <+ transition((V(in_bus[16 * block + bit]) > vth) ? vdd : 0.0, 0, tr, tr);
                if (block == 13) V(out13[bit]) <+ transition((V(in_bus[16 * block + bit]) > vth) ? vdd : 0.0, 0, tr, tr);
                if (block == 14) V(out14[bit]) <+ transition((V(in_bus[16 * block + bit]) > vth) ? vdd : 0.0, 0, tr, tr);
                if (block == 15) V(out15[bit]) <+ transition((V(in_bus[16 * block + bit]) > vth) ? vdd : 0.0, 0, tr, tr);
            end
        end
    end
endmodule
