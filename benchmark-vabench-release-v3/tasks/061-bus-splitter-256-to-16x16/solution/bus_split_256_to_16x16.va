`include "constants.vams"
`include "disciplines.vams"

module bus_split_256_to_16x16(
    input electrical [255:0] in_bus,
    output electrical [15:0] out15,
    output electrical [15:0] out14,
    output electrical [15:0] out13,
    output electrical [15:0] out12,
    output electrical [15:0] out11,
    output electrical [15:0] out10,
    output electrical [15:0] out9,
    output electrical [15:0] out8,
    output electrical [15:0] out7,
    output electrical [15:0] out6,
    output electrical [15:0] out5,
    output electrical [15:0] out4,
    output electrical [15:0] out3,
    output electrical [15:0] out2,
    output electrical [15:0] out1,
    output electrical [15:0] out0
);
    parameter real vdd = 0.9;
    parameter real vth = 0.45;
    parameter real tr = 20p;

    genvar bit;

    analog begin
        for (bit = 0; bit < 16; bit = bit + 1) begin
            V(out0[bit]) <+ transition((V(in_bus[0 + bit]) > vth) ? vdd : 0.0, 0, tr, tr);
            V(out1[bit]) <+ transition((V(in_bus[16 + bit]) > vth) ? vdd : 0.0, 0, tr, tr);
            V(out2[bit]) <+ transition((V(in_bus[32 + bit]) > vth) ? vdd : 0.0, 0, tr, tr);
            V(out3[bit]) <+ transition((V(in_bus[48 + bit]) > vth) ? vdd : 0.0, 0, tr, tr);
            V(out4[bit]) <+ transition((V(in_bus[64 + bit]) > vth) ? vdd : 0.0, 0, tr, tr);
            V(out5[bit]) <+ transition((V(in_bus[80 + bit]) > vth) ? vdd : 0.0, 0, tr, tr);
            V(out6[bit]) <+ transition((V(in_bus[96 + bit]) > vth) ? vdd : 0.0, 0, tr, tr);
            V(out7[bit]) <+ transition((V(in_bus[112 + bit]) > vth) ? vdd : 0.0, 0, tr, tr);
            V(out8[bit]) <+ transition((V(in_bus[128 + bit]) > vth) ? vdd : 0.0, 0, tr, tr);
            V(out9[bit]) <+ transition((V(in_bus[144 + bit]) > vth) ? vdd : 0.0, 0, tr, tr);
            V(out10[bit]) <+ transition((V(in_bus[160 + bit]) > vth) ? vdd : 0.0, 0, tr, tr);
            V(out11[bit]) <+ transition((V(in_bus[176 + bit]) > vth) ? vdd : 0.0, 0, tr, tr);
            V(out12[bit]) <+ transition((V(in_bus[192 + bit]) > vth) ? vdd : 0.0, 0, tr, tr);
            V(out13[bit]) <+ transition((V(in_bus[208 + bit]) > vth) ? vdd : 0.0, 0, tr, tr);
            V(out14[bit]) <+ transition((V(in_bus[224 + bit]) > vth) ? vdd : 0.0, 0, tr, tr);
            V(out15[bit]) <+ transition((V(in_bus[240 + bit]) > vth) ? vdd : 0.0, 0, tr, tr);
        end
    end
endmodule
