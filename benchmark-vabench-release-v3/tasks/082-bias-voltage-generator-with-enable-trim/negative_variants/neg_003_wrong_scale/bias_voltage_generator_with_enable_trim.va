`include "constants.vams"
`include "disciplines.vams"
module bias_voltage_generator_with_enable_trim(clk, rst, vin, out, metric);
    input electrical clk;
    input electrical rst;
    input electrical vin;
    output electrical out;
    output electrical metric;
    analog begin
        V(out) <+ 0;
        V(metric) <+ 0;
    end
endmodule
