simulator lang=spectre
global 0

ahdl_include "idtmod_phase_accumulator.va"

Vvin (vin 0) vsource dc=0.25 type=dc
Vmode (mode 0) vsource dc=0.4 type=dc
Vrst (rst 0) vsource dc=0.0 type=dc
Vclk (clk 0) vsource dc=0.0 type=dc

XDUT (vin clk mode rst out metric) idtmod_phase_accumulator

tran tran stop=1.0u
save vin clk mode rst out metric
