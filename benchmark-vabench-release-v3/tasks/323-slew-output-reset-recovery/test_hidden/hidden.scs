simulator lang=spectre
global 0

ahdl_include "slew_output_reset_recovery.va"

Vvin (vin 0) vsource type=pwl wave=[ 0n 0.0 70n 0.0 ]
Vmode (mode 0) vsource type=pwl wave=[ 0n 0.0 70n 0.0 ]
Vrst (rst 0) vsource type=pwl wave=[ 0n 0.9 12n 0.9 12.1n 0 34n 0 34.1n 0.9 44n 0.9 44.1n 0 70n 0 ]
Vclk (clk 0) vsource type=pwl wave=[ 0n 0 4.9n 0 5.0n 0.9 5.5n 0.9 5.6n 0 24.9n 0 25.0n 0.9 25.5n 0.9 25.6n 0 54.9n 0 55.0n 0.9 55.5n 0.9 55.6n 0 70n 0 ]

XDUT (vin clk mode rst out metric) slew_output_reset_recovery

tran tran stop=70n
save vin clk mode rst out metric
