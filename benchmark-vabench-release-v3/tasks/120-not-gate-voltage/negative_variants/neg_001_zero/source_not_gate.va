`include "constants.vams"
`include "disciplines.vams"

module source_not_gate(vin, vout);
    input vin;
    output vout;
    electrical vin, vout;
    parameter real vlogic_high = 0.9;
    parameter real vlogic_low = 0.0;
    parameter real vtrans = 0.45;
    parameter real tdel = 500p from [0:inf);
    parameter real trise = 20p from (0:inf);
    parameter real tfall = 20p from (0:inf);

    analog begin
        V(vout) <+ transition(vlogic_low, tdel, trise, tfall);
    end
endmodule
