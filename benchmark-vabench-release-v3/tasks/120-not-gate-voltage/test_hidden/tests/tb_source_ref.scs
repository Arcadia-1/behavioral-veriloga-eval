simulator lang=spectre
global 0

ahdl_include "source_not_gate.va"

Vin (vin 0) vsource type=pwl wave=[0 0.9 8n 0.9 8.1n 0 22n 0 22.1n 0.9 33n 0.9 33.1n 0 45n 0]

XDUT (vin vout) source_not_gate

tran tran stop=45n maxstep=50p
save vin vout
