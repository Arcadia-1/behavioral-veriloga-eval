`include "disciplines.vams"

module full_subtractor_logic (vin1, vin2, vin_borrow, vout_diff, vout_borrow);

input vin1, vin2, vin_borrow;
output vout_diff, vout_borrow;
electrical vin1, vin2, vin_borrow, vout_diff, vout_borrow;

analog begin
    V(vout_diff) <+ 0;
    V(vout_borrow) <+ 0;
end

endmodule
