`include "disciplines.vams"

module power_enable_turnon_delay_gate(clk, vdd, vss, vbias, en, pd, pwr_ok, drive_en, delay_mon);
input clk, vdd, vss, vbias, en, pd;
output pwr_ok, drive_en, delay_mon;
electrical clk, vdd, vss, vbias, en, pd, pwr_ok, drive_en, delay_mon;
parameter real vth = 0.45;
parameter real vhi = 0.9;
parameter real vdd_min = 0.75;
parameter real vdd_max = 1.05;
parameter real vbias_min = 0.25;
parameter real vbias_max = 0.75;
parameter integer delay_cycles = 3;
parameter real tr = 60p;
real ok_v;
analog begin
    ok_v = ((V(vdd, vss) >= vdd_min) && (V(vdd, vss) <= vdd_max) &&
            (V(vbias, vss) >= vbias_min) && (V(vbias, vss) <= vbias_max) &&
            (V(en) > vth) && (V(pd) <= vth)) ? vhi : 0.0;
    V(pwr_ok) <+ transition(ok_v, 0.0, tr, tr);
    V(drive_en) <+ transition(ok_v, 0.0, tr, tr);
    V(delay_mon) <+ transition(ok_v, 0.0, tr, tr);
end
endmodule
