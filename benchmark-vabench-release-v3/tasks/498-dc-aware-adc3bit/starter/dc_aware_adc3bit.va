`include "disciplines.vams"

module dc_aware_adc3bit(vin, d2, d1, d0);
input vin;
output d2, d1, d0;
electrical vin, d2, d1, d0;

analog begin
    V(d2) <+ 0.0;
    V(d1) <+ 0.0;
    V(d0) <+ 0.0;
end
endmodule
