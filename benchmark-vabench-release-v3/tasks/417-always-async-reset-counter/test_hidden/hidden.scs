simulator lang=spectre
global 0

ahdl_include "always_async_reset_counter.vams"

Vclk (clk 0) vsource type=pwl wave=[0 0.0 79n 0.0 80n 1.0 119n 1.0 120n 0.0 179n 0.0 180n 1.0 219n 1.0 220n 0.0 279n 0.0 280n 1.0 319n 1.0 320n 0.0 379n 0.0 380n 1.0 419n 1.0 420n 0.0 479n 0.0 480n 1.0 550n 1.0]
Vrst (rst 0) vsource type=pwl wave=[0 1.0 39n 1.0 40n 0.0 259n 0.0 260n 1.0 309n 1.0 310n 0.0 550n 0.0]
Ven (en 0) vsource type=pwl wave=[0 1.0 139n 1.0 140n 0.0 259n 0.0 260n 1.0 419n 1.0 420n 0.0 459n 0.0 460n 1.0 550n 1.0]

XDUT (clk rst en q) always_async_reset_counter

tran tran stop=550n
save clk rst en q
