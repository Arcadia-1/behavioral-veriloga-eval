`include "constants.vams"
`include "disciplines.vams"

module analog_primitive_resistor_instance (
    inout electrical p,
    inout electrical n
);
endmodule
