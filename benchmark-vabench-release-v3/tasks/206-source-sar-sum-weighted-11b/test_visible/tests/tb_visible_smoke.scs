simulator lang=spectre
global 0

ahdl_include "sar_sum_weighted_11b.va"

Vdin0 (din0 0) vsource type=pwl wave=[0 0 7.95n 0 8n 0.9 17.95n 0.9 18n 0 27.95n 0 28n 0.9]
Vdin1 (din1 0) vsource type=pwl wave=[0 0 17.95n 0 18n 0.9]
Vdin2 (din2 0) vsource type=pwl wave=[0 0 7.95n 0 8n 0.9]
Vdin3 (din3 0) vsource type=pwl wave=[0 0 17.95n 0 18n 0.9]
Vdin4 (din4 0) vsource type=pwl wave=[0 0 7.95n 0 8n 0.9 17.95n 0.9 18n 0 27.95n 0 28n 0.9]
Vdin5 (din5 0) vsource type=pwl wave=[0 0 27.95n 0 28n 0.9]
Vdin6 (din6 0) vsource type=pwl wave=[0 0 7.95n 0 8n 0.9]
Vdin7 (din7 0) vsource type=pwl wave=[0 0 17.95n 0 18n 0.9]
Vdin8 (din8 0) vsource type=pwl wave=[0 0 7.95n 0 8n 0.9 17.95n 0.9 18n 0 27.95n 0 28n 0.9]
Vdin9 (din9 0) vsource type=pwl wave=[0 0 17.95n 0 18n 0.9]
Vdin10 (din10 0) vsource type=pwl wave=[0 0 7.95n 0 8n 0.9 17.95n 0.9 18n 0 27.95n 0 28n 0.9]

XDUT (din0 din1 din2 din3 din4 din5 din6 din7 din8 din9 din10 vout) sar_sum_weighted_11b

tran tran stop=40n maxstep=20p
save din0 din1 din2 din3 din4 din5 din6 din7 din8 din9 din10 vout
