`include "disciplines.vams"

module clocked_dac_4b_binary (D1, D2, D3, D4, CLK, VOUT);

input D1, D2, D3, D4, CLK;
output VOUT;
electrical D1, D2, D3, D4, CLK, VOUT;

parameter real vth = 0.45;
parameter real lsb = 1.8 / 16.0;

real vout = 0;

analog begin
    @(cross(V(CLK) - vth, +1)) begin
        vout = 0;
        vout = vout + (V(D1) > vth) * 8;
        vout = vout + (V(D2) > vth) * 4;
        vout = vout + (V(D3) > vth) * 2;
        vout = vout + (V(D4) > vth) * 1;
        vout = (vout + 0.5) * lsb - 0.9;
    end

    V(VOUT) <+ transition(vout);
end

endmodule
