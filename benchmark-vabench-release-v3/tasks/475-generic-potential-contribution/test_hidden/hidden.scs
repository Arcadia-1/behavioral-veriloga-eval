simulator lang=spectre
global 0

ahdl_include "generic_potential_contribution.va"

Vin (inp 0) vsource type=pwl wave=[0 0.00 20n 0.00 21n 0.25 60n 0.25 61n 0.55 100n 0.55 101n -0.15 160n -0.15]

XDUT (inp out) generic_potential_contribution

tran tran stop=160n
save inp out
