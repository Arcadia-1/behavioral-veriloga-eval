`include "constants.vams"
`include "disciplines.vams"

module generic_potential_contribution (input electrical in, output electrical out);
analog begin
    potential(out) <+ transition(V(in), 0.0, 200p, 200p);
end
endmodule
