simulator lang=spectre
global 0

ahdl_include "amplifier_filter_chain.va"

Vclk (clk 0) vsource type=pulse val0=0 val1=0.9 period=1n delay=100p rise=50p fall=50p width=450p
Vrst (rst 0) vsource type=pulse val0=0.9 val1=0 period=20n delay=1n rise=50p fall=50p width=18n
Vvin (vin 0) vsource type=pulse val0=0.45 val1=0.9 period=3n delay=200p rise=50p fall=50p width=1.4n

XDUT (clk rst vin out metric preamp_mon filt1_mon filt2_mon settle_metric) amplifier_filter_chain

tran tran stop=5n maxstep=100p
save clk rst vin out metric preamp_mon filt1_mon filt2_mon settle_metric
