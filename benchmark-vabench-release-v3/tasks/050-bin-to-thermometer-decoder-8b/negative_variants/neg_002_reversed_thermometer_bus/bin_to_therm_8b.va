`include "constants.vams"
`include "disciplines.vams"

module bin_to_therm_8b(
    en,
    b7,
    b6,
    b5,
    b4,
    b3,
    b2,
    b1,
    b0,
    th255,
    th254,
    th253,
    th252,
    th251,
    th250,
    th249,
    th248,
    th247,
    th246,
    th245,
    th244,
    th243,
    th242,
    th241,
    th240,
    th239,
    th238,
    th237,
    th236,
    th235,
    th234,
    th233,
    th232,
    th231,
    th230,
    th229,
    th228,
    th227,
    th226,
    th225,
    th224,
    th223,
    th222,
    th221,
    th220,
    th219,
    th218,
    th217,
    th216,
    th215,
    th214,
    th213,
    th212,
    th211,
    th210,
    th209,
    th208,
    th207,
    th206,
    th205,
    th204,
    th203,
    th202,
    th201,
    th200,
    th199,
    th198,
    th197,
    th196,
    th195,
    th194,
    th193,
    th192,
    th191,
    th190,
    th189,
    th188,
    th187,
    th186,
    th185,
    th184,
    th183,
    th182,
    th181,
    th180,
    th179,
    th178,
    th177,
    th176,
    th175,
    th174,
    th173,
    th172,
    th171,
    th170,
    th169,
    th168,
    th167,
    th166,
    th165,
    th164,
    th163,
    th162,
    th161,
    th160,
    th159,
    th158,
    th157,
    th156,
    th155,
    th154,
    th153,
    th152,
    th151,
    th150,
    th149,
    th148,
    th147,
    th146,
    th145,
    th144,
    th143,
    th142,
    th141,
    th140,
    th139,
    th138,
    th137,
    th136,
    th135,
    th134,
    th133,
    th132,
    th131,
    th130,
    th129,
    th128,
    th127,
    th126,
    th125,
    th124,
    th123,
    th122,
    th121,
    th120,
    th119,
    th118,
    th117,
    th116,
    th115,
    th114,
    th113,
    th112,
    th111,
    th110,
    th109,
    th108,
    th107,
    th106,
    th105,
    th104,
    th103,
    th102,
    th101,
    th100,
    th99,
    th98,
    th97,
    th96,
    th95,
    th94,
    th93,
    th92,
    th91,
    th90,
    th89,
    th88,
    th87,
    th86,
    th85,
    th84,
    th83,
    th82,
    th81,
    th80,
    th79,
    th78,
    th77,
    th76,
    th75,
    th74,
    th73,
    th72,
    th71,
    th70,
    th69,
    th68,
    th67,
    th66,
    th65,
    th64,
    th63,
    th62,
    th61,
    th60,
    th59,
    th58,
    th57,
    th56,
    th55,
    th54,
    th53,
    th52,
    th51,
    th50,
    th49,
    th48,
    th47,
    th46,
    th45,
    th44,
    th43,
    th42,
    th41,
    th40,
    th39,
    th38,
    th37,
    th36,
    th35,
    th34,
    th33,
    th32,
    th31,
    th30,
    th29,
    th28,
    th27,
    th26,
    th25,
    th24,
    th23,
    th22,
    th21,
    th20,
    th19,
    th18,
    th17,
    th16,
    th15,
    th14,
    th13,
    th12,
    th11,
    th10,
    th9,
    th8,
    th7,
    th6,
    th5,
    th4,
    th3,
    th2,
    th1,
    th0
);
    input en, b7, b6, b5, b4, b3, b2, b1, b0;
    output th255, th254, th253, th252, th251, th250, th249, th248, th247, th246, th245, th244, th243, th242, th241, th240, th239, th238, th237, th236, th235, th234, th233, th232, th231, th230, th229, th228, th227, th226, th225, th224, th223, th222, th221, th220, th219, th218, th217, th216, th215, th214, th213, th212, th211, th210, th209, th208, th207, th206, th205, th204, th203, th202, th201, th200, th199, th198, th197, th196, th195, th194, th193, th192, th191, th190, th189, th188, th187, th186, th185, th184, th183, th182, th181, th180, th179, th178, th177, th176, th175, th174, th173, th172, th171, th170, th169, th168, th167, th166, th165, th164, th163, th162, th161, th160, th159, th158, th157, th156, th155, th154, th153, th152, th151, th150, th149, th148, th147, th146, th145, th144, th143, th142, th141, th140, th139, th138, th137, th136, th135, th134, th133, th132, th131, th130, th129, th128, th127, th126, th125, th124, th123, th122, th121, th120, th119, th118, th117, th116, th115, th114, th113, th112, th111, th110, th109, th108, th107, th106, th105, th104, th103, th102, th101, th100, th99, th98, th97, th96, th95, th94, th93, th92, th91, th90, th89, th88, th87, th86, th85, th84, th83, th82, th81, th80, th79, th78, th77, th76, th75, th74, th73, th72, th71, th70, th69, th68, th67, th66, th65, th64, th63, th62, th61, th60, th59, th58, th57, th56, th55, th54, th53, th52, th51, th50, th49, th48, th47, th46, th45, th44, th43, th42, th41, th40, th39, th38, th37, th36, th35, th34, th33, th32, th31, th30, th29, th28, th27, th26, th25, th24, th23, th22, th21, th20, th19, th18, th17, th16, th15, th14, th13, th12, th11, th10, th9, th8, th7, th6, th5, th4, th3, th2, th1, th0;
    electrical en, b7, b6, b5, b4, b3, b2, b1, b0, th255, th254, th253, th252, th251, th250, th249, th248, th247, th246, th245, th244, th243, th242, th241, th240, th239, th238, th237, th236, th235, th234, th233, th232, th231, th230, th229, th228, th227, th226, th225, th224, th223, th222, th221, th220, th219, th218, th217, th216, th215, th214, th213, th212, th211, th210, th209, th208, th207, th206, th205, th204, th203, th202, th201, th200, th199, th198, th197, th196, th195, th194, th193, th192, th191, th190, th189, th188, th187, th186, th185, th184, th183, th182, th181, th180, th179, th178, th177, th176, th175, th174, th173, th172, th171, th170, th169, th168, th167, th166, th165, th164, th163, th162, th161, th160, th159, th158, th157, th156, th155, th154, th153, th152, th151, th150, th149, th148, th147, th146, th145, th144, th143, th142, th141, th140, th139, th138, th137, th136, th135, th134, th133, th132, th131, th130, th129, th128, th127, th126, th125, th124, th123, th122, th121, th120, th119, th118, th117, th116, th115, th114, th113, th112, th111, th110, th109, th108, th107, th106, th105, th104, th103, th102, th101, th100, th99, th98, th97, th96, th95, th94, th93, th92, th91, th90, th89, th88, th87, th86, th85, th84, th83, th82, th81, th80, th79, th78, th77, th76, th75, th74, th73, th72, th71, th70, th69, th68, th67, th66, th65, th64, th63, th62, th61, th60, th59, th58, th57, th56, th55, th54, th53, th52, th51, th50, th49, th48, th47, th46, th45, th44, th43, th42, th41, th40, th39, th38, th37, th36, th35, th34, th33, th32, th31, th30, th29, th28, th27, th26, th25, th24, th23, th22, th21, th20, th19, th18, th17, th16, th15, th14, th13, th12, th11, th10, th9, th8, th7, th6, th5, th4, th3, th2, th1, th0;
    parameter real vdd = 0.9;
    parameter real vth = 0.45;
    parameter real tr = 20p;
    integer code;
    analog begin
        code = 0;
        if (V(b0) > vth) code = code + 1;
        if (V(b1) > vth) code = code + 2;
        if (V(b2) > vth) code = code + 4;
        if (V(b3) > vth) code = code + 8;
        if (V(b4) > vth) code = code + 16;
        if (V(b5) > vth) code = code + 32;
        if (V(b6) > vth) code = code + 64;
        if (V(b7) > vth) code = code + 128;
        V(th0) <+ transition((V(en) > vth && code > (255 - 0)) ? vdd : 0.0, 0, tr, tr);
        V(th1) <+ transition((V(en) > vth && code > (255 - 1)) ? vdd : 0.0, 0, tr, tr);
        V(th2) <+ transition((V(en) > vth && code > (255 - 2)) ? vdd : 0.0, 0, tr, tr);
        V(th3) <+ transition((V(en) > vth && code > (255 - 3)) ? vdd : 0.0, 0, tr, tr);
        V(th4) <+ transition((V(en) > vth && code > (255 - 4)) ? vdd : 0.0, 0, tr, tr);
        V(th5) <+ transition((V(en) > vth && code > (255 - 5)) ? vdd : 0.0, 0, tr, tr);
        V(th6) <+ transition((V(en) > vth && code > (255 - 6)) ? vdd : 0.0, 0, tr, tr);
        V(th7) <+ transition((V(en) > vth && code > (255 - 7)) ? vdd : 0.0, 0, tr, tr);
        V(th8) <+ transition((V(en) > vth && code > (255 - 8)) ? vdd : 0.0, 0, tr, tr);
        V(th9) <+ transition((V(en) > vth && code > (255 - 9)) ? vdd : 0.0, 0, tr, tr);
        V(th10) <+ transition((V(en) > vth && code > (255 - 10)) ? vdd : 0.0, 0, tr, tr);
        V(th11) <+ transition((V(en) > vth && code > (255 - 11)) ? vdd : 0.0, 0, tr, tr);
        V(th12) <+ transition((V(en) > vth && code > (255 - 12)) ? vdd : 0.0, 0, tr, tr);
        V(th13) <+ transition((V(en) > vth && code > (255 - 13)) ? vdd : 0.0, 0, tr, tr);
        V(th14) <+ transition((V(en) > vth && code > (255 - 14)) ? vdd : 0.0, 0, tr, tr);
        V(th15) <+ transition((V(en) > vth && code > (255 - 15)) ? vdd : 0.0, 0, tr, tr);
        V(th16) <+ transition((V(en) > vth && code > (255 - 16)) ? vdd : 0.0, 0, tr, tr);
        V(th17) <+ transition((V(en) > vth && code > (255 - 17)) ? vdd : 0.0, 0, tr, tr);
        V(th18) <+ transition((V(en) > vth && code > (255 - 18)) ? vdd : 0.0, 0, tr, tr);
        V(th19) <+ transition((V(en) > vth && code > (255 - 19)) ? vdd : 0.0, 0, tr, tr);
        V(th20) <+ transition((V(en) > vth && code > (255 - 20)) ? vdd : 0.0, 0, tr, tr);
        V(th21) <+ transition((V(en) > vth && code > (255 - 21)) ? vdd : 0.0, 0, tr, tr);
        V(th22) <+ transition((V(en) > vth && code > (255 - 22)) ? vdd : 0.0, 0, tr, tr);
        V(th23) <+ transition((V(en) > vth && code > (255 - 23)) ? vdd : 0.0, 0, tr, tr);
        V(th24) <+ transition((V(en) > vth && code > (255 - 24)) ? vdd : 0.0, 0, tr, tr);
        V(th25) <+ transition((V(en) > vth && code > (255 - 25)) ? vdd : 0.0, 0, tr, tr);
        V(th26) <+ transition((V(en) > vth && code > (255 - 26)) ? vdd : 0.0, 0, tr, tr);
        V(th27) <+ transition((V(en) > vth && code > (255 - 27)) ? vdd : 0.0, 0, tr, tr);
        V(th28) <+ transition((V(en) > vth && code > (255 - 28)) ? vdd : 0.0, 0, tr, tr);
        V(th29) <+ transition((V(en) > vth && code > (255 - 29)) ? vdd : 0.0, 0, tr, tr);
        V(th30) <+ transition((V(en) > vth && code > (255 - 30)) ? vdd : 0.0, 0, tr, tr);
        V(th31) <+ transition((V(en) > vth && code > (255 - 31)) ? vdd : 0.0, 0, tr, tr);
        V(th32) <+ transition((V(en) > vth && code > (255 - 32)) ? vdd : 0.0, 0, tr, tr);
        V(th33) <+ transition((V(en) > vth && code > (255 - 33)) ? vdd : 0.0, 0, tr, tr);
        V(th34) <+ transition((V(en) > vth && code > (255 - 34)) ? vdd : 0.0, 0, tr, tr);
        V(th35) <+ transition((V(en) > vth && code > (255 - 35)) ? vdd : 0.0, 0, tr, tr);
        V(th36) <+ transition((V(en) > vth && code > (255 - 36)) ? vdd : 0.0, 0, tr, tr);
        V(th37) <+ transition((V(en) > vth && code > (255 - 37)) ? vdd : 0.0, 0, tr, tr);
        V(th38) <+ transition((V(en) > vth && code > (255 - 38)) ? vdd : 0.0, 0, tr, tr);
        V(th39) <+ transition((V(en) > vth && code > (255 - 39)) ? vdd : 0.0, 0, tr, tr);
        V(th40) <+ transition((V(en) > vth && code > (255 - 40)) ? vdd : 0.0, 0, tr, tr);
        V(th41) <+ transition((V(en) > vth && code > (255 - 41)) ? vdd : 0.0, 0, tr, tr);
        V(th42) <+ transition((V(en) > vth && code > (255 - 42)) ? vdd : 0.0, 0, tr, tr);
        V(th43) <+ transition((V(en) > vth && code > (255 - 43)) ? vdd : 0.0, 0, tr, tr);
        V(th44) <+ transition((V(en) > vth && code > (255 - 44)) ? vdd : 0.0, 0, tr, tr);
        V(th45) <+ transition((V(en) > vth && code > (255 - 45)) ? vdd : 0.0, 0, tr, tr);
        V(th46) <+ transition((V(en) > vth && code > (255 - 46)) ? vdd : 0.0, 0, tr, tr);
        V(th47) <+ transition((V(en) > vth && code > (255 - 47)) ? vdd : 0.0, 0, tr, tr);
        V(th48) <+ transition((V(en) > vth && code > (255 - 48)) ? vdd : 0.0, 0, tr, tr);
        V(th49) <+ transition((V(en) > vth && code > (255 - 49)) ? vdd : 0.0, 0, tr, tr);
        V(th50) <+ transition((V(en) > vth && code > (255 - 50)) ? vdd : 0.0, 0, tr, tr);
        V(th51) <+ transition((V(en) > vth && code > (255 - 51)) ? vdd : 0.0, 0, tr, tr);
        V(th52) <+ transition((V(en) > vth && code > (255 - 52)) ? vdd : 0.0, 0, tr, tr);
        V(th53) <+ transition((V(en) > vth && code > (255 - 53)) ? vdd : 0.0, 0, tr, tr);
        V(th54) <+ transition((V(en) > vth && code > (255 - 54)) ? vdd : 0.0, 0, tr, tr);
        V(th55) <+ transition((V(en) > vth && code > (255 - 55)) ? vdd : 0.0, 0, tr, tr);
        V(th56) <+ transition((V(en) > vth && code > (255 - 56)) ? vdd : 0.0, 0, tr, tr);
        V(th57) <+ transition((V(en) > vth && code > (255 - 57)) ? vdd : 0.0, 0, tr, tr);
        V(th58) <+ transition((V(en) > vth && code > (255 - 58)) ? vdd : 0.0, 0, tr, tr);
        V(th59) <+ transition((V(en) > vth && code > (255 - 59)) ? vdd : 0.0, 0, tr, tr);
        V(th60) <+ transition((V(en) > vth && code > (255 - 60)) ? vdd : 0.0, 0, tr, tr);
        V(th61) <+ transition((V(en) > vth && code > (255 - 61)) ? vdd : 0.0, 0, tr, tr);
        V(th62) <+ transition((V(en) > vth && code > (255 - 62)) ? vdd : 0.0, 0, tr, tr);
        V(th63) <+ transition((V(en) > vth && code > (255 - 63)) ? vdd : 0.0, 0, tr, tr);
        V(th64) <+ transition((V(en) > vth && code > (255 - 64)) ? vdd : 0.0, 0, tr, tr);
        V(th65) <+ transition((V(en) > vth && code > (255 - 65)) ? vdd : 0.0, 0, tr, tr);
        V(th66) <+ transition((V(en) > vth && code > (255 - 66)) ? vdd : 0.0, 0, tr, tr);
        V(th67) <+ transition((V(en) > vth && code > (255 - 67)) ? vdd : 0.0, 0, tr, tr);
        V(th68) <+ transition((V(en) > vth && code > (255 - 68)) ? vdd : 0.0, 0, tr, tr);
        V(th69) <+ transition((V(en) > vth && code > (255 - 69)) ? vdd : 0.0, 0, tr, tr);
        V(th70) <+ transition((V(en) > vth && code > (255 - 70)) ? vdd : 0.0, 0, tr, tr);
        V(th71) <+ transition((V(en) > vth && code > (255 - 71)) ? vdd : 0.0, 0, tr, tr);
        V(th72) <+ transition((V(en) > vth && code > (255 - 72)) ? vdd : 0.0, 0, tr, tr);
        V(th73) <+ transition((V(en) > vth && code > (255 - 73)) ? vdd : 0.0, 0, tr, tr);
        V(th74) <+ transition((V(en) > vth && code > (255 - 74)) ? vdd : 0.0, 0, tr, tr);
        V(th75) <+ transition((V(en) > vth && code > (255 - 75)) ? vdd : 0.0, 0, tr, tr);
        V(th76) <+ transition((V(en) > vth && code > (255 - 76)) ? vdd : 0.0, 0, tr, tr);
        V(th77) <+ transition((V(en) > vth && code > (255 - 77)) ? vdd : 0.0, 0, tr, tr);
        V(th78) <+ transition((V(en) > vth && code > (255 - 78)) ? vdd : 0.0, 0, tr, tr);
        V(th79) <+ transition((V(en) > vth && code > (255 - 79)) ? vdd : 0.0, 0, tr, tr);
        V(th80) <+ transition((V(en) > vth && code > (255 - 80)) ? vdd : 0.0, 0, tr, tr);
        V(th81) <+ transition((V(en) > vth && code > (255 - 81)) ? vdd : 0.0, 0, tr, tr);
        V(th82) <+ transition((V(en) > vth && code > (255 - 82)) ? vdd : 0.0, 0, tr, tr);
        V(th83) <+ transition((V(en) > vth && code > (255 - 83)) ? vdd : 0.0, 0, tr, tr);
        V(th84) <+ transition((V(en) > vth && code > (255 - 84)) ? vdd : 0.0, 0, tr, tr);
        V(th85) <+ transition((V(en) > vth && code > (255 - 85)) ? vdd : 0.0, 0, tr, tr);
        V(th86) <+ transition((V(en) > vth && code > (255 - 86)) ? vdd : 0.0, 0, tr, tr);
        V(th87) <+ transition((V(en) > vth && code > (255 - 87)) ? vdd : 0.0, 0, tr, tr);
        V(th88) <+ transition((V(en) > vth && code > (255 - 88)) ? vdd : 0.0, 0, tr, tr);
        V(th89) <+ transition((V(en) > vth && code > (255 - 89)) ? vdd : 0.0, 0, tr, tr);
        V(th90) <+ transition((V(en) > vth && code > (255 - 90)) ? vdd : 0.0, 0, tr, tr);
        V(th91) <+ transition((V(en) > vth && code > (255 - 91)) ? vdd : 0.0, 0, tr, tr);
        V(th92) <+ transition((V(en) > vth && code > (255 - 92)) ? vdd : 0.0, 0, tr, tr);
        V(th93) <+ transition((V(en) > vth && code > (255 - 93)) ? vdd : 0.0, 0, tr, tr);
        V(th94) <+ transition((V(en) > vth && code > (255 - 94)) ? vdd : 0.0, 0, tr, tr);
        V(th95) <+ transition((V(en) > vth && code > (255 - 95)) ? vdd : 0.0, 0, tr, tr);
        V(th96) <+ transition((V(en) > vth && code > (255 - 96)) ? vdd : 0.0, 0, tr, tr);
        V(th97) <+ transition((V(en) > vth && code > (255 - 97)) ? vdd : 0.0, 0, tr, tr);
        V(th98) <+ transition((V(en) > vth && code > (255 - 98)) ? vdd : 0.0, 0, tr, tr);
        V(th99) <+ transition((V(en) > vth && code > (255 - 99)) ? vdd : 0.0, 0, tr, tr);
        V(th100) <+ transition((V(en) > vth && code > (255 - 100)) ? vdd : 0.0, 0, tr, tr);
        V(th101) <+ transition((V(en) > vth && code > (255 - 101)) ? vdd : 0.0, 0, tr, tr);
        V(th102) <+ transition((V(en) > vth && code > (255 - 102)) ? vdd : 0.0, 0, tr, tr);
        V(th103) <+ transition((V(en) > vth && code > (255 - 103)) ? vdd : 0.0, 0, tr, tr);
        V(th104) <+ transition((V(en) > vth && code > (255 - 104)) ? vdd : 0.0, 0, tr, tr);
        V(th105) <+ transition((V(en) > vth && code > (255 - 105)) ? vdd : 0.0, 0, tr, tr);
        V(th106) <+ transition((V(en) > vth && code > (255 - 106)) ? vdd : 0.0, 0, tr, tr);
        V(th107) <+ transition((V(en) > vth && code > (255 - 107)) ? vdd : 0.0, 0, tr, tr);
        V(th108) <+ transition((V(en) > vth && code > (255 - 108)) ? vdd : 0.0, 0, tr, tr);
        V(th109) <+ transition((V(en) > vth && code > (255 - 109)) ? vdd : 0.0, 0, tr, tr);
        V(th110) <+ transition((V(en) > vth && code > (255 - 110)) ? vdd : 0.0, 0, tr, tr);
        V(th111) <+ transition((V(en) > vth && code > (255 - 111)) ? vdd : 0.0, 0, tr, tr);
        V(th112) <+ transition((V(en) > vth && code > (255 - 112)) ? vdd : 0.0, 0, tr, tr);
        V(th113) <+ transition((V(en) > vth && code > (255 - 113)) ? vdd : 0.0, 0, tr, tr);
        V(th114) <+ transition((V(en) > vth && code > (255 - 114)) ? vdd : 0.0, 0, tr, tr);
        V(th115) <+ transition((V(en) > vth && code > (255 - 115)) ? vdd : 0.0, 0, tr, tr);
        V(th116) <+ transition((V(en) > vth && code > (255 - 116)) ? vdd : 0.0, 0, tr, tr);
        V(th117) <+ transition((V(en) > vth && code > (255 - 117)) ? vdd : 0.0, 0, tr, tr);
        V(th118) <+ transition((V(en) > vth && code > (255 - 118)) ? vdd : 0.0, 0, tr, tr);
        V(th119) <+ transition((V(en) > vth && code > (255 - 119)) ? vdd : 0.0, 0, tr, tr);
        V(th120) <+ transition((V(en) > vth && code > (255 - 120)) ? vdd : 0.0, 0, tr, tr);
        V(th121) <+ transition((V(en) > vth && code > (255 - 121)) ? vdd : 0.0, 0, tr, tr);
        V(th122) <+ transition((V(en) > vth && code > (255 - 122)) ? vdd : 0.0, 0, tr, tr);
        V(th123) <+ transition((V(en) > vth && code > (255 - 123)) ? vdd : 0.0, 0, tr, tr);
        V(th124) <+ transition((V(en) > vth && code > (255 - 124)) ? vdd : 0.0, 0, tr, tr);
        V(th125) <+ transition((V(en) > vth && code > (255 - 125)) ? vdd : 0.0, 0, tr, tr);
        V(th126) <+ transition((V(en) > vth && code > (255 - 126)) ? vdd : 0.0, 0, tr, tr);
        V(th127) <+ transition((V(en) > vth && code > (255 - 127)) ? vdd : 0.0, 0, tr, tr);
        V(th128) <+ transition((V(en) > vth && code > (255 - 128)) ? vdd : 0.0, 0, tr, tr);
        V(th129) <+ transition((V(en) > vth && code > (255 - 129)) ? vdd : 0.0, 0, tr, tr);
        V(th130) <+ transition((V(en) > vth && code > (255 - 130)) ? vdd : 0.0, 0, tr, tr);
        V(th131) <+ transition((V(en) > vth && code > (255 - 131)) ? vdd : 0.0, 0, tr, tr);
        V(th132) <+ transition((V(en) > vth && code > (255 - 132)) ? vdd : 0.0, 0, tr, tr);
        V(th133) <+ transition((V(en) > vth && code > (255 - 133)) ? vdd : 0.0, 0, tr, tr);
        V(th134) <+ transition((V(en) > vth && code > (255 - 134)) ? vdd : 0.0, 0, tr, tr);
        V(th135) <+ transition((V(en) > vth && code > (255 - 135)) ? vdd : 0.0, 0, tr, tr);
        V(th136) <+ transition((V(en) > vth && code > (255 - 136)) ? vdd : 0.0, 0, tr, tr);
        V(th137) <+ transition((V(en) > vth && code > (255 - 137)) ? vdd : 0.0, 0, tr, tr);
        V(th138) <+ transition((V(en) > vth && code > (255 - 138)) ? vdd : 0.0, 0, tr, tr);
        V(th139) <+ transition((V(en) > vth && code > (255 - 139)) ? vdd : 0.0, 0, tr, tr);
        V(th140) <+ transition((V(en) > vth && code > (255 - 140)) ? vdd : 0.0, 0, tr, tr);
        V(th141) <+ transition((V(en) > vth && code > (255 - 141)) ? vdd : 0.0, 0, tr, tr);
        V(th142) <+ transition((V(en) > vth && code > (255 - 142)) ? vdd : 0.0, 0, tr, tr);
        V(th143) <+ transition((V(en) > vth && code > (255 - 143)) ? vdd : 0.0, 0, tr, tr);
        V(th144) <+ transition((V(en) > vth && code > (255 - 144)) ? vdd : 0.0, 0, tr, tr);
        V(th145) <+ transition((V(en) > vth && code > (255 - 145)) ? vdd : 0.0, 0, tr, tr);
        V(th146) <+ transition((V(en) > vth && code > (255 - 146)) ? vdd : 0.0, 0, tr, tr);
        V(th147) <+ transition((V(en) > vth && code > (255 - 147)) ? vdd : 0.0, 0, tr, tr);
        V(th148) <+ transition((V(en) > vth && code > (255 - 148)) ? vdd : 0.0, 0, tr, tr);
        V(th149) <+ transition((V(en) > vth && code > (255 - 149)) ? vdd : 0.0, 0, tr, tr);
        V(th150) <+ transition((V(en) > vth && code > (255 - 150)) ? vdd : 0.0, 0, tr, tr);
        V(th151) <+ transition((V(en) > vth && code > (255 - 151)) ? vdd : 0.0, 0, tr, tr);
        V(th152) <+ transition((V(en) > vth && code > (255 - 152)) ? vdd : 0.0, 0, tr, tr);
        V(th153) <+ transition((V(en) > vth && code > (255 - 153)) ? vdd : 0.0, 0, tr, tr);
        V(th154) <+ transition((V(en) > vth && code > (255 - 154)) ? vdd : 0.0, 0, tr, tr);
        V(th155) <+ transition((V(en) > vth && code > (255 - 155)) ? vdd : 0.0, 0, tr, tr);
        V(th156) <+ transition((V(en) > vth && code > (255 - 156)) ? vdd : 0.0, 0, tr, tr);
        V(th157) <+ transition((V(en) > vth && code > (255 - 157)) ? vdd : 0.0, 0, tr, tr);
        V(th158) <+ transition((V(en) > vth && code > (255 - 158)) ? vdd : 0.0, 0, tr, tr);
        V(th159) <+ transition((V(en) > vth && code > (255 - 159)) ? vdd : 0.0, 0, tr, tr);
        V(th160) <+ transition((V(en) > vth && code > (255 - 160)) ? vdd : 0.0, 0, tr, tr);
        V(th161) <+ transition((V(en) > vth && code > (255 - 161)) ? vdd : 0.0, 0, tr, tr);
        V(th162) <+ transition((V(en) > vth && code > (255 - 162)) ? vdd : 0.0, 0, tr, tr);
        V(th163) <+ transition((V(en) > vth && code > (255 - 163)) ? vdd : 0.0, 0, tr, tr);
        V(th164) <+ transition((V(en) > vth && code > (255 - 164)) ? vdd : 0.0, 0, tr, tr);
        V(th165) <+ transition((V(en) > vth && code > (255 - 165)) ? vdd : 0.0, 0, tr, tr);
        V(th166) <+ transition((V(en) > vth && code > (255 - 166)) ? vdd : 0.0, 0, tr, tr);
        V(th167) <+ transition((V(en) > vth && code > (255 - 167)) ? vdd : 0.0, 0, tr, tr);
        V(th168) <+ transition((V(en) > vth && code > (255 - 168)) ? vdd : 0.0, 0, tr, tr);
        V(th169) <+ transition((V(en) > vth && code > (255 - 169)) ? vdd : 0.0, 0, tr, tr);
        V(th170) <+ transition((V(en) > vth && code > (255 - 170)) ? vdd : 0.0, 0, tr, tr);
        V(th171) <+ transition((V(en) > vth && code > (255 - 171)) ? vdd : 0.0, 0, tr, tr);
        V(th172) <+ transition((V(en) > vth && code > (255 - 172)) ? vdd : 0.0, 0, tr, tr);
        V(th173) <+ transition((V(en) > vth && code > (255 - 173)) ? vdd : 0.0, 0, tr, tr);
        V(th174) <+ transition((V(en) > vth && code > (255 - 174)) ? vdd : 0.0, 0, tr, tr);
        V(th175) <+ transition((V(en) > vth && code > (255 - 175)) ? vdd : 0.0, 0, tr, tr);
        V(th176) <+ transition((V(en) > vth && code > (255 - 176)) ? vdd : 0.0, 0, tr, tr);
        V(th177) <+ transition((V(en) > vth && code > (255 - 177)) ? vdd : 0.0, 0, tr, tr);
        V(th178) <+ transition((V(en) > vth && code > (255 - 178)) ? vdd : 0.0, 0, tr, tr);
        V(th179) <+ transition((V(en) > vth && code > (255 - 179)) ? vdd : 0.0, 0, tr, tr);
        V(th180) <+ transition((V(en) > vth && code > (255 - 180)) ? vdd : 0.0, 0, tr, tr);
        V(th181) <+ transition((V(en) > vth && code > (255 - 181)) ? vdd : 0.0, 0, tr, tr);
        V(th182) <+ transition((V(en) > vth && code > (255 - 182)) ? vdd : 0.0, 0, tr, tr);
        V(th183) <+ transition((V(en) > vth && code > (255 - 183)) ? vdd : 0.0, 0, tr, tr);
        V(th184) <+ transition((V(en) > vth && code > (255 - 184)) ? vdd : 0.0, 0, tr, tr);
        V(th185) <+ transition((V(en) > vth && code > (255 - 185)) ? vdd : 0.0, 0, tr, tr);
        V(th186) <+ transition((V(en) > vth && code > (255 - 186)) ? vdd : 0.0, 0, tr, tr);
        V(th187) <+ transition((V(en) > vth && code > (255 - 187)) ? vdd : 0.0, 0, tr, tr);
        V(th188) <+ transition((V(en) > vth && code > (255 - 188)) ? vdd : 0.0, 0, tr, tr);
        V(th189) <+ transition((V(en) > vth && code > (255 - 189)) ? vdd : 0.0, 0, tr, tr);
        V(th190) <+ transition((V(en) > vth && code > (255 - 190)) ? vdd : 0.0, 0, tr, tr);
        V(th191) <+ transition((V(en) > vth && code > (255 - 191)) ? vdd : 0.0, 0, tr, tr);
        V(th192) <+ transition((V(en) > vth && code > (255 - 192)) ? vdd : 0.0, 0, tr, tr);
        V(th193) <+ transition((V(en) > vth && code > (255 - 193)) ? vdd : 0.0, 0, tr, tr);
        V(th194) <+ transition((V(en) > vth && code > (255 - 194)) ? vdd : 0.0, 0, tr, tr);
        V(th195) <+ transition((V(en) > vth && code > (255 - 195)) ? vdd : 0.0, 0, tr, tr);
        V(th196) <+ transition((V(en) > vth && code > (255 - 196)) ? vdd : 0.0, 0, tr, tr);
        V(th197) <+ transition((V(en) > vth && code > (255 - 197)) ? vdd : 0.0, 0, tr, tr);
        V(th198) <+ transition((V(en) > vth && code > (255 - 198)) ? vdd : 0.0, 0, tr, tr);
        V(th199) <+ transition((V(en) > vth && code > (255 - 199)) ? vdd : 0.0, 0, tr, tr);
        V(th200) <+ transition((V(en) > vth && code > (255 - 200)) ? vdd : 0.0, 0, tr, tr);
        V(th201) <+ transition((V(en) > vth && code > (255 - 201)) ? vdd : 0.0, 0, tr, tr);
        V(th202) <+ transition((V(en) > vth && code > (255 - 202)) ? vdd : 0.0, 0, tr, tr);
        V(th203) <+ transition((V(en) > vth && code > (255 - 203)) ? vdd : 0.0, 0, tr, tr);
        V(th204) <+ transition((V(en) > vth && code > (255 - 204)) ? vdd : 0.0, 0, tr, tr);
        V(th205) <+ transition((V(en) > vth && code > (255 - 205)) ? vdd : 0.0, 0, tr, tr);
        V(th206) <+ transition((V(en) > vth && code > (255 - 206)) ? vdd : 0.0, 0, tr, tr);
        V(th207) <+ transition((V(en) > vth && code > (255 - 207)) ? vdd : 0.0, 0, tr, tr);
        V(th208) <+ transition((V(en) > vth && code > (255 - 208)) ? vdd : 0.0, 0, tr, tr);
        V(th209) <+ transition((V(en) > vth && code > (255 - 209)) ? vdd : 0.0, 0, tr, tr);
        V(th210) <+ transition((V(en) > vth && code > (255 - 210)) ? vdd : 0.0, 0, tr, tr);
        V(th211) <+ transition((V(en) > vth && code > (255 - 211)) ? vdd : 0.0, 0, tr, tr);
        V(th212) <+ transition((V(en) > vth && code > (255 - 212)) ? vdd : 0.0, 0, tr, tr);
        V(th213) <+ transition((V(en) > vth && code > (255 - 213)) ? vdd : 0.0, 0, tr, tr);
        V(th214) <+ transition((V(en) > vth && code > (255 - 214)) ? vdd : 0.0, 0, tr, tr);
        V(th215) <+ transition((V(en) > vth && code > (255 - 215)) ? vdd : 0.0, 0, tr, tr);
        V(th216) <+ transition((V(en) > vth && code > (255 - 216)) ? vdd : 0.0, 0, tr, tr);
        V(th217) <+ transition((V(en) > vth && code > (255 - 217)) ? vdd : 0.0, 0, tr, tr);
        V(th218) <+ transition((V(en) > vth && code > (255 - 218)) ? vdd : 0.0, 0, tr, tr);
        V(th219) <+ transition((V(en) > vth && code > (255 - 219)) ? vdd : 0.0, 0, tr, tr);
        V(th220) <+ transition((V(en) > vth && code > (255 - 220)) ? vdd : 0.0, 0, tr, tr);
        V(th221) <+ transition((V(en) > vth && code > (255 - 221)) ? vdd : 0.0, 0, tr, tr);
        V(th222) <+ transition((V(en) > vth && code > (255 - 222)) ? vdd : 0.0, 0, tr, tr);
        V(th223) <+ transition((V(en) > vth && code > (255 - 223)) ? vdd : 0.0, 0, tr, tr);
        V(th224) <+ transition((V(en) > vth && code > (255 - 224)) ? vdd : 0.0, 0, tr, tr);
        V(th225) <+ transition((V(en) > vth && code > (255 - 225)) ? vdd : 0.0, 0, tr, tr);
        V(th226) <+ transition((V(en) > vth && code > (255 - 226)) ? vdd : 0.0, 0, tr, tr);
        V(th227) <+ transition((V(en) > vth && code > (255 - 227)) ? vdd : 0.0, 0, tr, tr);
        V(th228) <+ transition((V(en) > vth && code > (255 - 228)) ? vdd : 0.0, 0, tr, tr);
        V(th229) <+ transition((V(en) > vth && code > (255 - 229)) ? vdd : 0.0, 0, tr, tr);
        V(th230) <+ transition((V(en) > vth && code > (255 - 230)) ? vdd : 0.0, 0, tr, tr);
        V(th231) <+ transition((V(en) > vth && code > (255 - 231)) ? vdd : 0.0, 0, tr, tr);
        V(th232) <+ transition((V(en) > vth && code > (255 - 232)) ? vdd : 0.0, 0, tr, tr);
        V(th233) <+ transition((V(en) > vth && code > (255 - 233)) ? vdd : 0.0, 0, tr, tr);
        V(th234) <+ transition((V(en) > vth && code > (255 - 234)) ? vdd : 0.0, 0, tr, tr);
        V(th235) <+ transition((V(en) > vth && code > (255 - 235)) ? vdd : 0.0, 0, tr, tr);
        V(th236) <+ transition((V(en) > vth && code > (255 - 236)) ? vdd : 0.0, 0, tr, tr);
        V(th237) <+ transition((V(en) > vth && code > (255 - 237)) ? vdd : 0.0, 0, tr, tr);
        V(th238) <+ transition((V(en) > vth && code > (255 - 238)) ? vdd : 0.0, 0, tr, tr);
        V(th239) <+ transition((V(en) > vth && code > (255 - 239)) ? vdd : 0.0, 0, tr, tr);
        V(th240) <+ transition((V(en) > vth && code > (255 - 240)) ? vdd : 0.0, 0, tr, tr);
        V(th241) <+ transition((V(en) > vth && code > (255 - 241)) ? vdd : 0.0, 0, tr, tr);
        V(th242) <+ transition((V(en) > vth && code > (255 - 242)) ? vdd : 0.0, 0, tr, tr);
        V(th243) <+ transition((V(en) > vth && code > (255 - 243)) ? vdd : 0.0, 0, tr, tr);
        V(th244) <+ transition((V(en) > vth && code > (255 - 244)) ? vdd : 0.0, 0, tr, tr);
        V(th245) <+ transition((V(en) > vth && code > (255 - 245)) ? vdd : 0.0, 0, tr, tr);
        V(th246) <+ transition((V(en) > vth && code > (255 - 246)) ? vdd : 0.0, 0, tr, tr);
        V(th247) <+ transition((V(en) > vth && code > (255 - 247)) ? vdd : 0.0, 0, tr, tr);
        V(th248) <+ transition((V(en) > vth && code > (255 - 248)) ? vdd : 0.0, 0, tr, tr);
        V(th249) <+ transition((V(en) > vth && code > (255 - 249)) ? vdd : 0.0, 0, tr, tr);
        V(th250) <+ transition((V(en) > vth && code > (255 - 250)) ? vdd : 0.0, 0, tr, tr);
        V(th251) <+ transition((V(en) > vth && code > (255 - 251)) ? vdd : 0.0, 0, tr, tr);
        V(th252) <+ transition((V(en) > vth && code > (255 - 252)) ? vdd : 0.0, 0, tr, tr);
        V(th253) <+ transition((V(en) > vth && code > (255 - 253)) ? vdd : 0.0, 0, tr, tr);
        V(th254) <+ transition((V(en) > vth && code > (255 - 254)) ? vdd : 0.0, 0, tr, tr);
        V(th255) <+ transition((V(en) > vth && code > (255 - 255)) ? vdd : 0.0, 0, tr, tr);
    end
endmodule
