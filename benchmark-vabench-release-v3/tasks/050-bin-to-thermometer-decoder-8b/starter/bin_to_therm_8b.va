`include "constants.vams"
`include "disciplines.vams"

module bin_to_therm_8b(
    input electrical en,
    input electrical [7:0] b,
    output electrical [255:0] th
);
    parameter real vdd = 0.9;
    parameter real vth = 0.45;
    parameter real tr = 20p;

    genvar i;

    analog begin
        for (i = 0; i < 256; i = i + 1) begin
            V(th[i]) <+ transition(0.0, 0, tr, tr);
        end
    end
endmodule
