`include "disciplines.vams"
module l3_sar2_logic_7b(clk, dp, dn, cmpck, do0, do1, do2, do3, do4, do5, do6, sp1, sp2, sp3, sp4, sp5, sp6, sn1, sn2, sn3, sn4, sn5, sn6);
input clk, dp, dn;
output cmpck, do0, do1, do2, do3, do4, do5, do6, sp1, sp2, sp3, sp4, sp5, sp6, sn1, sn2, sn3, sn4, sn5, sn6;
electrical clk, dp, dn, cmpck, do0, do1, do2, do3, do4, do5, do6, sp1, sp2, sp3, sp4, sp5, sp6, sn1, sn2, sn3, sn4, sn5, sn6;
parameter real vdd = 0.9;
parameter real t_logic_delay = 10p;
integer step, cmpck_i;
integer dout0, dout1, dout2, dout3, dout4, dout5, dout6;
integer out0, out1, out2, out3, out4, out5, out6;
integer cp1, cp2, cp3, cp4, cp5, cp6, cn1, cn2, cn3, cn4, cn5, cn6;
analog begin
    @(initial_step or cross(V(clk) - vdd / 2.0, -1)) begin
        cmpck_i = 0;
        step = 6;
        dout0 = 0; dout1 = 0; dout2 = 0; dout3 = 0; dout4 = 0; dout5 = 0; dout6 = 0;
        out0 = 0; out1 = 0; out2 = 0; out3 = 0; out4 = 0; out5 = 0; out6 = 0;
        cp1 = 0; cp2 = 0; cp3 = 0; cp4 = 0; cp5 = 0; cp6 = 1;
        cn1 = 0; cn2 = 0; cn3 = 0; cn4 = 0; cn5 = 0; cn6 = 1;
    end
    @(cross(V(clk) - vdd / 2.0, +1)) cmpck_i = 1;
    @(cross(V(dp) - vdd / 2.0, -1) or cross(V(dn) - vdd / 2.0, -1)) begin
        cmpck_i = 0;
        if (step == 6) dout6 = V(dp) > V(dn); else if (step == 5) dout5 = V(dp) > V(dn); else if (step == 4) dout4 = V(dp) > V(dn); else if (step == 3) dout3 = V(dp) > V(dn); else if (step == 2) dout2 = V(dp) > V(dn); else if (step == 1) dout1 = V(dp) > V(dn); else if (step == 0) dout0 = V(dp) > V(dn);
        if (step >= 1) begin
            if (step == 6) begin
                if (V(dp) > V(dn)) cn6 = 0; else cp6 = 0;
            end else if (V(dp) > V(dn)) begin
                if (step == 5) cp5 = 1; else if (step == 4) cp4 = 1; else if (step == 3) cp3 = 1; else if (step == 2) cp2 = 1; else if (step == 1) cp1 = 1;
            end else begin
                if (step == 5) cn5 = 1; else if (step == 4) cn4 = 1; else if (step == 3) cn3 = 1; else if (step == 2) cn2 = 1; else if (step == 1) cn1 = 1;
            end
        end
    end
    @(cross(V(dp) - vdd / 2.0, +1) or cross(V(dn) - vdd / 2.0, +1)) begin
        step = step - 1;
        if (step == -1) begin
            out0 = dout0; out1 = dout1; out2 = dout2; out3 = dout3; out4 = dout4; out5 = dout5; out6 = dout6;
        end
        if (step >= 0 && V(clk) > vdd / 2.0) cmpck_i = 1;
    end
    V(cmpck) <+ transition(cmpck_i * vdd, t_logic_delay, 10p, 10p);
    V(do0) <+ transition(out0 * vdd, 0, 10p, 10p); V(do1) <+ transition(out1 * vdd, 0, 10p, 10p); V(do2) <+ transition(out2 * vdd, 0, 10p, 10p); V(do3) <+ transition(out3 * vdd, 0, 10p, 10p); V(do4) <+ transition(out4 * vdd, 0, 10p, 10p); V(do5) <+ transition(out5 * vdd, 0, 10p, 10p); V(do6) <+ transition(out6 * vdd, 0, 10p, 10p);
    V(sp1) <+ transition(cp1 * vdd, 0, 10p, 10p); V(sp2) <+ transition(cp2 * vdd, 0, 10p, 10p); V(sp3) <+ transition(cp3 * vdd, 0, 10p, 10p); V(sp4) <+ transition(cp4 * vdd, 0, 10p, 10p); V(sp5) <+ transition(cp5 * vdd, 0, 10p, 10p); V(sp6) <+ transition(cp6 * vdd, 0, 10p, 10p);
    V(sn1) <+ transition(cn1 * vdd, 0, 10p, 10p); V(sn2) <+ transition(cn2 * vdd, 0, 10p, 10p); V(sn3) <+ transition(cn3 * vdd, 0, 10p, 10p); V(sn4) <+ transition(cn4 * vdd, 0, 10p, 10p); V(sn5) <+ transition(cn5 * vdd, 0, 10p, 10p); V(sn6) <+ transition(cn6 * vdd, 0, 10p, 10p);
end
endmodule
