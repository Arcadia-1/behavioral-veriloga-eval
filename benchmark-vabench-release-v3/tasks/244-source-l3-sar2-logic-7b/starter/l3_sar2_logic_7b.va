`include "disciplines.vams"
module l3_sar2_logic_7b(clk, dp, dn, cmpck, do0, do1, do2, do3, do4, do5, do6, sp1, sp2, sp3, sp4, sp5, sp6, sn1, sn2, sn3, sn4, sn5, sn6);
input clk, dp, dn;
output cmpck, do0, do1, do2, do3, do4, do5, do6, sp1, sp2, sp3, sp4, sp5, sp6, sn1, sn2, sn3, sn4, sn5, sn6;
electrical clk, dp, dn, cmpck, do0, do1, do2, do3, do4, do5, do6, sp1, sp2, sp3, sp4, sp5, sp6, sn1, sn2, sn3, sn4, sn5, sn6;
analog begin
    V(cmpck) <+ 0.0; V(do0) <+ 0.0; V(do1) <+ 0.0; V(do2) <+ 0.0; V(do3) <+ 0.0; V(do4) <+ 0.0; V(do5) <+ 0.0; V(do6) <+ 0.0;
    V(sp1) <+ 0.0; V(sp2) <+ 0.0; V(sp3) <+ 0.0; V(sp4) <+ 0.0; V(sp5) <+ 0.0; V(sp6) <+ 0.0;
    V(sn1) <+ 0.0; V(sn2) <+ 0.0; V(sn3) <+ 0.0; V(sn4) <+ 0.0; V(sn5) <+ 0.0; V(sn6) <+ 0.0;
end
endmodule
