`include "constants.vams"
`include "disciplines.vams"
`ifndef V3_GAIN_MODE
`define V3_GAIN_VALUE 0.75
`elsif V3_ALT_MODE
`define V3_GAIN_VALUE 1.25
`else
`define V3_GAIN_VALUE 1.0
`endif
`undef V3_GAIN_MODE

module preprocessor_ifndef_elsif_undef (
    input  electrical vin,
    input  electrical clk,
    input  electrical mode,
    input  electrical rst,
    output electrical out,
    output electrical metric
);
parameter real vth = 0.45;
parameter real vhi = 0.9;
parameter real tr = 200p;
real out_v;
real metric_v;
integer count_q;
analog begin
    @(initial_step) begin
        out_v = 0.0;
        metric_v = 0.0;
        count_q = 0;
    end
    @(cross(V(clk) - vth, +1)) begin
        if (V(rst) > vth) begin
            out_v = 0.0;
            metric_v = 0.0;
            count_q = 0;
        end else begin
            out_v = `V3_GAIN_VALUE * V(vin);
            metric_v = `V3_GAIN_VALUE;
            count_q = count_q + 1;
        end
    end
    V(out) <+ transition(out_v, 0.0, tr, tr);
    V(metric) <+ transition(metric_v, 0.0, tr, tr);
end
endmodule
