simulator lang=spectre
global 0

ahdl_include "recursive_function_candidate.va"

XDUT (out) recursive_function_candidate

tran tran stop=20n
save out
