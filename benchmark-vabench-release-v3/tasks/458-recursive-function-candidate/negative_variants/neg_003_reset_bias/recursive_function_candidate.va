`include "constants.vams"
`include "disciplines.vams"
module recursive_function_candidate(output electrical out);
function real fact;
    input integer n;
    begin
        if (n <= 1) fact = 1.0;
        else fact = n * fact(n - 1);
    end
endfunction
analog begin
    V(out) <+ (V(rst) > 0.45 ? 0.25 : (fact(3)));
end
endmodule
