simulator lang=spectre
global 0

ahdl_include "recursive_function_candidate.va"

Vstim (stim 0) vsource dc=1.0
XDUT (out) recursive_function_candidate depth=4

tran tran stop=20n
save stim out
