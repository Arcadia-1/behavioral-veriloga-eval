simulator lang=spectre
global 0
ahdl_include "l2_sar_logic_4b.va"
Vclks (clks 0) vsource type=pulse val0=0 val1=1.1 delay=0.05n period=20n width=0.25n rise=20p fall=20p
Vclkc (clkc 0) vsource type=pulse val0=0 val1=1.1 delay=0.7n period=20n width=0.25n rise=20p fall=20p
Vp (dcmpp 0) vsource type=pwl wave=[0 0 1.12n 0 1.14n 1.1 1.38n 1.1 1.40n 0 2.34n 0 2.36n 1.1 2.60n 1.1 2.62n 0 5n 0]
Vn (dcmpn 0) vsource type=pwl wave=[0 0 1.72n 0 1.74n 1.1 1.98n 1.1 2.00n 0 2.94n 0 2.96n 1.1 3.20n 1.1 3.22n 0 5n 0]
XDUT (clkc clks dcmpp dcmpn cmpck do0 do1 do2 do3 dctrlp1 dctrlp2 dctrlp3 dctrln1 dctrln2 dctrln3) l2_sar_logic_4b
tran tran stop=4.6n maxstep=10p
save clkc clks dcmpp dcmpn cmpck do0 do1 do2 do3 dctrlp1 dctrlp2 dctrlp3 dctrln1 dctrln2 dctrln3
