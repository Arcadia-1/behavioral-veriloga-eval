`include "constants.vams"
`include "disciplines.vams"

module analysis_dependent_noise_enable (
    input  electrical ctrl,
    input  electrical clk,
    output electrical out,
    output electrical metric
);
parameter real vth = 0.45;
parameter real vhi = 0.9;
parameter real tr = 200p;
parameter real noise_power = 1.0e-12;
real metric_v;

analog begin
    @(initial_step) begin
        metric_v = 0.0;
    end

    V(out) <+ transition(0.0, 0.0, tr, tr);
    if (analysis("noise")) V(out) <+ white_noise(noise_power, "enabled_noise");

    @(cross(V(clk)-vth,+1)) metric_v = V(ctrl);

    V(metric) <+ transition(metric_v, 0.0, tr, tr);
end
endmodule
