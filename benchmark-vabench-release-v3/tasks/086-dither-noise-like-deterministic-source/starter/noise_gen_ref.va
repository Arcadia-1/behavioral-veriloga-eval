`include "constants.vams"
`include "disciplines.vams"

module noise_gen (
    input electrical  vin_i,
    output electrical vout_o
);

    parameter real sigma = 0.01;
    parameter real dt    = 0.5n;

    analog begin
        V(vout_o) <+ transition(0.0, 0, dt/10, dt/10);
    end

endmodule
