`include "constants.vams"
`include "disciplines.vams"
module noise_gen(vin_i, vout_o);
    input electrical vin_i;
    output electrical vout_o;
    analog begin
        V(vout_o) <+ V(vin_i);
    end
endmodule
