`include "constants.vams"
`include "disciplines.vams"

module nested_function_pipeline (
    input  electrical vin,
    output electrical out
);
analog begin
    V(out) <+ 0.0;
end
endmodule
