`include "constants.vams"
`include "disciplines.vams"
module bound_step_period_guard_ref(VDD, VSS, guard_out, phase_out);
    inout electrical VDD;
    inout electrical VSS;
    output electrical guard_out;
    output electrical phase_out;
    analog begin
        V(guard_out) <+ 0;
        V(phase_out) <+ 0;
    end
endmodule
