`include "constants.vams"
`include "disciplines.vams"
module bound_step_period_guard_ref (VDD, VSS, vin, vout);
    inout electrical VDD, VSS;
    input electrical vin;
    output electrical vout;
    analog begin
        V(vout) <+ V(VDD)/2;
    end
endmodule
