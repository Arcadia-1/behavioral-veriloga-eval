`include "disciplines.vams"

module dac7_code_generator(clks, din0, din1, din2, din3, din4, din5, din6);
input clks;
output din0, din1, din2, din3, din4, din5, din6;
electrical clks, din0, din1, din2, din3, din4, din5, din6;

parameter real vlo = 0;
parameter real vhi = 0.9;
parameter real vth = 0.45;
parameter real tt = 20p;
integer counter;
integer b0, b1, b2, b3, b4, b5, b6;

analog begin
    @(initial_step) begin
        counter = 0;
        b0 = 0; b1 = 0; b2 = 0; b3 = 0; b4 = 0; b5 = 0; b6 = 0;
    end
    @(cross(V(clks) - vth, +1)) begin
        counter = counter + 1;
        if (counter > 255)
            counter = 0;
        b0 = 1 - ((counter >> 7) & 1);
        b1 = 1 - ((counter >> 6) & 1);
        b2 = 1 - ((counter >> 5) & 1);
        b3 = 1 - ((counter >> 4) & 1);
        b4 = 1 - ((counter >> 3) & 1);
        b5 = 1 - ((counter >> 2) & 1);
        b6 = 1 - ((counter >> 1) & 1);
    end
    V(din0) <+ transition(b0 ? vhi : vlo, 0, tt, tt);
    V(din1) <+ transition(b1 ? vhi : vlo, 0, tt, tt);
    V(din2) <+ transition(b2 ? vhi : vlo, 0, tt, tt);
    V(din3) <+ transition(b3 ? vhi : vlo, 0, tt, tt);
    V(din4) <+ transition(b4 ? vhi : vlo, 0, tt, tt);
    V(din5) <+ transition(b5 ? vhi : vlo, 0, tt, tt);
    V(din6) <+ transition(b6 ? vhi : vlo, 0, tt, tt);
end

endmodule
