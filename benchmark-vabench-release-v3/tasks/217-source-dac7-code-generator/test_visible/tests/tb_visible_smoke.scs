simulator lang=spectre
global 0

ahdl_include "dac7_code_generator.va"

Vclks (clks 0) vsource type=pulse val0=0 val1=0.9 delay=1n period=1n width=0.4n rise=20p fall=20p

XDUT (clks din0 din1 din2 din3 din4 din5 din6) dac7_code_generator

tran tran stop=10n maxstep=20p
save clks din0 din1 din2 din3 din4 din5 din6
