`include "constants.vams"
`include "disciplines.vams"

module masked_config_update_32b(
    old31,
    old30,
    old29,
    old28,
    old27,
    old26,
    old25,
    old24,
    old23,
    old22,
    old21,
    old20,
    old19,
    old18,
    old17,
    old16,
    old15,
    old14,
    old13,
    old12,
    old11,
    old10,
    old9,
    old8,
    old7,
    old6,
    old5,
    old4,
    old3,
    old2,
    old1,
    old0,
    new31,
    new30,
    new29,
    new28,
    new27,
    new26,
    new25,
    new24,
    new23,
    new22,
    new21,
    new20,
    new19,
    new18,
    new17,
    new16,
    new15,
    new14,
    new13,
    new12,
    new11,
    new10,
    new9,
    new8,
    new7,
    new6,
    new5,
    new4,
    new3,
    new2,
    new1,
    new0,
    mask31,
    mask30,
    mask29,
    mask28,
    mask27,
    mask26,
    mask25,
    mask24,
    mask23,
    mask22,
    mask21,
    mask20,
    mask19,
    mask18,
    mask17,
    mask16,
    mask15,
    mask14,
    mask13,
    mask12,
    mask11,
    mask10,
    mask9,
    mask8,
    mask7,
    mask6,
    mask5,
    mask4,
    mask3,
    mask2,
    mask1,
    mask0,
    out31,
    out30,
    out29,
    out28,
    out27,
    out26,
    out25,
    out24,
    out23,
    out22,
    out21,
    out20,
    out19,
    out18,
    out17,
    out16,
    out15,
    out14,
    out13,
    out12,
    out11,
    out10,
    out9,
    out8,
    out7,
    out6,
    out5,
    out4,
    out3,
    out2,
    out1,
    out0
);
    input old31, old30, old29, old28, old27, old26, old25, old24, old23, old22, old21, old20, old19, old18, old17, old16, old15, old14, old13, old12, old11, old10, old9, old8, old7, old6, old5, old4, old3, old2, old1, old0, new31, new30, new29, new28, new27, new26, new25, new24, new23, new22, new21, new20, new19, new18, new17, new16, new15, new14, new13, new12, new11, new10, new9, new8, new7, new6, new5, new4, new3, new2, new1, new0, mask31, mask30, mask29, mask28, mask27, mask26, mask25, mask24, mask23, mask22, mask21, mask20, mask19, mask18, mask17, mask16, mask15, mask14, mask13, mask12, mask11, mask10, mask9, mask8, mask7, mask6, mask5, mask4, mask3, mask2, mask1, mask0;
    output out31, out30, out29, out28, out27, out26, out25, out24, out23, out22, out21, out20, out19, out18, out17, out16, out15, out14, out13, out12, out11, out10, out9, out8, out7, out6, out5, out4, out3, out2, out1, out0;
    electrical old31, old30, old29, old28, old27, old26, old25, old24, old23, old22, old21, old20, old19, old18, old17, old16, old15, old14, old13, old12, old11, old10, old9, old8, old7, old6, old5, old4, old3, old2, old1, old0, new31, new30, new29, new28, new27, new26, new25, new24, new23, new22, new21, new20, new19, new18, new17, new16, new15, new14, new13, new12, new11, new10, new9, new8, new7, new6, new5, new4, new3, new2, new1, new0, mask31, mask30, mask29, mask28, mask27, mask26, mask25, mask24, mask23, mask22, mask21, mask20, mask19, mask18, mask17, mask16, mask15, mask14, mask13, mask12, mask11, mask10, mask9, mask8, mask7, mask6, mask5, mask4, mask3, mask2, mask1, mask0, out31, out30, out29, out28, out27, out26, out25, out24, out23, out22, out21, out20, out19, out18, out17, out16, out15, out14, out13, out12, out11, out10, out9, out8, out7, out6, out5, out4, out3, out2, out1, out0;
    parameter real vdd = 0.9;
    parameter real vth = 0.45;
    parameter real tr = 20p;
    analog begin
        V(out31) <+ transition(0.0, 0, tr, tr);
        V(out30) <+ transition(0.0, 0, tr, tr);
        V(out29) <+ transition(0.0, 0, tr, tr);
        V(out28) <+ transition(0.0, 0, tr, tr);
        V(out27) <+ transition(0.0, 0, tr, tr);
        V(out26) <+ transition(0.0, 0, tr, tr);
        V(out25) <+ transition(0.0, 0, tr, tr);
        V(out24) <+ transition(0.0, 0, tr, tr);
        V(out23) <+ transition(0.0, 0, tr, tr);
        V(out22) <+ transition(0.0, 0, tr, tr);
        V(out21) <+ transition(0.0, 0, tr, tr);
        V(out20) <+ transition(0.0, 0, tr, tr);
        V(out19) <+ transition(0.0, 0, tr, tr);
        V(out18) <+ transition(0.0, 0, tr, tr);
        V(out17) <+ transition(0.0, 0, tr, tr);
        V(out16) <+ transition(0.0, 0, tr, tr);
        V(out15) <+ transition(0.0, 0, tr, tr);
        V(out14) <+ transition(0.0, 0, tr, tr);
        V(out13) <+ transition(0.0, 0, tr, tr);
        V(out12) <+ transition(0.0, 0, tr, tr);
        V(out11) <+ transition(0.0, 0, tr, tr);
        V(out10) <+ transition(0.0, 0, tr, tr);
        V(out9) <+ transition(0.0, 0, tr, tr);
        V(out8) <+ transition(0.0, 0, tr, tr);
        V(out7) <+ transition(0.0, 0, tr, tr);
        V(out6) <+ transition(0.0, 0, tr, tr);
        V(out5) <+ transition(0.0, 0, tr, tr);
        V(out4) <+ transition(0.0, 0, tr, tr);
        V(out3) <+ transition(0.0, 0, tr, tr);
        V(out2) <+ transition(0.0, 0, tr, tr);
        V(out1) <+ transition(0.0, 0, tr, tr);
        V(out0) <+ transition(0.0, 0, tr, tr);
    end
endmodule
