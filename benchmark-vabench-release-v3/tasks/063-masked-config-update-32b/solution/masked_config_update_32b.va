`include "constants.vams"
`include "disciplines.vams"

module masked_config_update_32b(
    old31,
    old30,
    old29,
    old28,
    old27,
    old26,
    old25,
    old24,
    old23,
    old22,
    old21,
    old20,
    old19,
    old18,
    old17,
    old16,
    old15,
    old14,
    old13,
    old12,
    old11,
    old10,
    old9,
    old8,
    old7,
    old6,
    old5,
    old4,
    old3,
    old2,
    old1,
    old0,
    new31,
    new30,
    new29,
    new28,
    new27,
    new26,
    new25,
    new24,
    new23,
    new22,
    new21,
    new20,
    new19,
    new18,
    new17,
    new16,
    new15,
    new14,
    new13,
    new12,
    new11,
    new10,
    new9,
    new8,
    new7,
    new6,
    new5,
    new4,
    new3,
    new2,
    new1,
    new0,
    mask31,
    mask30,
    mask29,
    mask28,
    mask27,
    mask26,
    mask25,
    mask24,
    mask23,
    mask22,
    mask21,
    mask20,
    mask19,
    mask18,
    mask17,
    mask16,
    mask15,
    mask14,
    mask13,
    mask12,
    mask11,
    mask10,
    mask9,
    mask8,
    mask7,
    mask6,
    mask5,
    mask4,
    mask3,
    mask2,
    mask1,
    mask0,
    out31,
    out30,
    out29,
    out28,
    out27,
    out26,
    out25,
    out24,
    out23,
    out22,
    out21,
    out20,
    out19,
    out18,
    out17,
    out16,
    out15,
    out14,
    out13,
    out12,
    out11,
    out10,
    out9,
    out8,
    out7,
    out6,
    out5,
    out4,
    out3,
    out2,
    out1,
    out0
);
    input old31, old30, old29, old28, old27, old26, old25, old24, old23, old22, old21, old20, old19, old18, old17, old16, old15, old14, old13, old12, old11, old10, old9, old8, old7, old6, old5, old4, old3, old2, old1, old0, new31, new30, new29, new28, new27, new26, new25, new24, new23, new22, new21, new20, new19, new18, new17, new16, new15, new14, new13, new12, new11, new10, new9, new8, new7, new6, new5, new4, new3, new2, new1, new0, mask31, mask30, mask29, mask28, mask27, mask26, mask25, mask24, mask23, mask22, mask21, mask20, mask19, mask18, mask17, mask16, mask15, mask14, mask13, mask12, mask11, mask10, mask9, mask8, mask7, mask6, mask5, mask4, mask3, mask2, mask1, mask0;
    output out31, out30, out29, out28, out27, out26, out25, out24, out23, out22, out21, out20, out19, out18, out17, out16, out15, out14, out13, out12, out11, out10, out9, out8, out7, out6, out5, out4, out3, out2, out1, out0;
    electrical old31, old30, old29, old28, old27, old26, old25, old24, old23, old22, old21, old20, old19, old18, old17, old16, old15, old14, old13, old12, old11, old10, old9, old8, old7, old6, old5, old4, old3, old2, old1, old0, new31, new30, new29, new28, new27, new26, new25, new24, new23, new22, new21, new20, new19, new18, new17, new16, new15, new14, new13, new12, new11, new10, new9, new8, new7, new6, new5, new4, new3, new2, new1, new0, mask31, mask30, mask29, mask28, mask27, mask26, mask25, mask24, mask23, mask22, mask21, mask20, mask19, mask18, mask17, mask16, mask15, mask14, mask13, mask12, mask11, mask10, mask9, mask8, mask7, mask6, mask5, mask4, mask3, mask2, mask1, mask0, out31, out30, out29, out28, out27, out26, out25, out24, out23, out22, out21, out20, out19, out18, out17, out16, out15, out14, out13, out12, out11, out10, out9, out8, out7, out6, out5, out4, out3, out2, out1, out0;
    parameter real vdd = 0.9;
    parameter real vth = 0.45;
    parameter real tr = 20p;
    analog begin
        V(out0) <+ transition((V(mask0) > vth ? V(new0) : V(old0)) > vth ? vdd : 0.0, 0, tr, tr);
        V(out1) <+ transition((V(mask1) > vth ? V(new1) : V(old1)) > vth ? vdd : 0.0, 0, tr, tr);
        V(out2) <+ transition((V(mask2) > vth ? V(new2) : V(old2)) > vth ? vdd : 0.0, 0, tr, tr);
        V(out3) <+ transition((V(mask3) > vth ? V(new3) : V(old3)) > vth ? vdd : 0.0, 0, tr, tr);
        V(out4) <+ transition((V(mask4) > vth ? V(new4) : V(old4)) > vth ? vdd : 0.0, 0, tr, tr);
        V(out5) <+ transition((V(mask5) > vth ? V(new5) : V(old5)) > vth ? vdd : 0.0, 0, tr, tr);
        V(out6) <+ transition((V(mask6) > vth ? V(new6) : V(old6)) > vth ? vdd : 0.0, 0, tr, tr);
        V(out7) <+ transition((V(mask7) > vth ? V(new7) : V(old7)) > vth ? vdd : 0.0, 0, tr, tr);
        V(out8) <+ transition((V(mask8) > vth ? V(new8) : V(old8)) > vth ? vdd : 0.0, 0, tr, tr);
        V(out9) <+ transition((V(mask9) > vth ? V(new9) : V(old9)) > vth ? vdd : 0.0, 0, tr, tr);
        V(out10) <+ transition((V(mask10) > vth ? V(new10) : V(old10)) > vth ? vdd : 0.0, 0, tr, tr);
        V(out11) <+ transition((V(mask11) > vth ? V(new11) : V(old11)) > vth ? vdd : 0.0, 0, tr, tr);
        V(out12) <+ transition((V(mask12) > vth ? V(new12) : V(old12)) > vth ? vdd : 0.0, 0, tr, tr);
        V(out13) <+ transition((V(mask13) > vth ? V(new13) : V(old13)) > vth ? vdd : 0.0, 0, tr, tr);
        V(out14) <+ transition((V(mask14) > vth ? V(new14) : V(old14)) > vth ? vdd : 0.0, 0, tr, tr);
        V(out15) <+ transition((V(mask15) > vth ? V(new15) : V(old15)) > vth ? vdd : 0.0, 0, tr, tr);
        V(out16) <+ transition((V(mask16) > vth ? V(new16) : V(old16)) > vth ? vdd : 0.0, 0, tr, tr);
        V(out17) <+ transition((V(mask17) > vth ? V(new17) : V(old17)) > vth ? vdd : 0.0, 0, tr, tr);
        V(out18) <+ transition((V(mask18) > vth ? V(new18) : V(old18)) > vth ? vdd : 0.0, 0, tr, tr);
        V(out19) <+ transition((V(mask19) > vth ? V(new19) : V(old19)) > vth ? vdd : 0.0, 0, tr, tr);
        V(out20) <+ transition((V(mask20) > vth ? V(new20) : V(old20)) > vth ? vdd : 0.0, 0, tr, tr);
        V(out21) <+ transition((V(mask21) > vth ? V(new21) : V(old21)) > vth ? vdd : 0.0, 0, tr, tr);
        V(out22) <+ transition((V(mask22) > vth ? V(new22) : V(old22)) > vth ? vdd : 0.0, 0, tr, tr);
        V(out23) <+ transition((V(mask23) > vth ? V(new23) : V(old23)) > vth ? vdd : 0.0, 0, tr, tr);
        V(out24) <+ transition((V(mask24) > vth ? V(new24) : V(old24)) > vth ? vdd : 0.0, 0, tr, tr);
        V(out25) <+ transition((V(mask25) > vth ? V(new25) : V(old25)) > vth ? vdd : 0.0, 0, tr, tr);
        V(out26) <+ transition((V(mask26) > vth ? V(new26) : V(old26)) > vth ? vdd : 0.0, 0, tr, tr);
        V(out27) <+ transition((V(mask27) > vth ? V(new27) : V(old27)) > vth ? vdd : 0.0, 0, tr, tr);
        V(out28) <+ transition((V(mask28) > vth ? V(new28) : V(old28)) > vth ? vdd : 0.0, 0, tr, tr);
        V(out29) <+ transition((V(mask29) > vth ? V(new29) : V(old29)) > vth ? vdd : 0.0, 0, tr, tr);
        V(out30) <+ transition((V(mask30) > vth ? V(new30) : V(old30)) > vth ? vdd : 0.0, 0, tr, tr);
        V(out31) <+ transition((V(mask31) > vth ? V(new31) : V(old31)) > vth ? vdd : 0.0, 0, tr, tr);
    end
endmodule
