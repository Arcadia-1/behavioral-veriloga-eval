`include "constants.vams"
`include "disciplines.vams"

module file_fopen_mode_selector (
    input  electrical vin,
    input  electrical clk,
    input  electrical mode,
    input  electrical rst,
    output electrical out,
    output electrical metric
);
parameter real vth = 0.45;
parameter real vhi = 0.9;
parameter real tr = 200p;
real out_v;
real metric_v;
integer mode_hit_q;
integer fd;
string line_buf;
analog begin
    @(initial_step) begin
        out_v = 0.0;
        metric_v = 0.0;
        mode_hit_q = 0;
        fd = $fopen("config_lines.txt", "r");
        $fgets(line_buf, fd);
        $fclose(fd);
        if (line_buf == "gain=0.8") mode_hit_q = 1;
    end
    @(cross(V(clk) - vth, +1)) begin
        out_v = 0.0;
    end
    V(out) <+ transition(out_v, 0.0, tr, tr);
    V(metric) <+ transition(metric_v, 0.0, tr, tr);
end
endmodule
