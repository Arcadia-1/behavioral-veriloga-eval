`include "constants.vams"
`include "disciplines.vams"

module file_fopen_mode_selector (
    input  electrical vin,
    input  electrical clk,
    input  electrical mode,
    input  electrical rst,
    output electrical out,
    output electrical metric
);
parameter real vth = 0.45;
parameter real vhi = 0.9;
parameter real tr = 200p;
real out_v;
real metric_v;
real gain_value;
integer mode_hit_q;
integer fd;
integer parsed_count;
string line_buf;
analog begin
    @(initial_step) begin
        out_v = 0.0;
        metric_v = 0.0;
        mode_hit_q = 0;
        gain_value = 0.0;
        parsed_count = 0;
        fd = $fopen("config_lines.txt", "r");
        $fgets(line_buf, fd);
        $fclose(fd);
        parsed_count = $sscanf(line_buf, "gain=%f", gain_value);
        if ((parsed_count == 1) && (gain_value > 0.799999) && (gain_value < 0.800001)) mode_hit_q = 1;
        else mode_hit_q = 0;
        if (mode_hit_q != 0) metric_v = vhi;
        else metric_v = 0.0;
    end
    @(cross(V(clk) - vth, +1)) begin
        if (V(rst) > vth) begin
            out_v = 0.0;
        end else begin
            if ((mode_hit_q != 0) && (V(vin) > vth)) out_v = vhi;
            else out_v = 0.0;
        end
    end
    V(out) <+ transition(out_v, 0.0, tr, tr);
    V(metric) <+ transition(metric_v, 0.0, tr, tr);
end
endmodule
