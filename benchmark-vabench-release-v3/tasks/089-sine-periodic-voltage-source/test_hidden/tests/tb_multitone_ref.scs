simulator lang=spectre
global 0

XDUT (OUT) multitone

tran tran stop=650n maxstep=400p
save OUT

ahdl_include "multitone.va"
