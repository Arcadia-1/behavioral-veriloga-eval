`include "constants.vams"
`include "disciplines.vams"
module multitone(OUT);
    output electrical OUT;
    analog begin
        V(OUT) <+ 0;
    end
endmodule
