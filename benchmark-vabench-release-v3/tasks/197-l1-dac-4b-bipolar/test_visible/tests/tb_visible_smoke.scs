simulator lang=spectre
global 0

ahdl_include "l1_dac_4b_bipolar.va"

Vrdy (rdy 0) vsource type=pwl wave=[0 0 1n 0 1.05n 1.0 1.50n 1.0 1.55n 0 11n 0 11.05n 1.0 11.50n 1.0 11.55n 0 21n 0 21.05n 1.0 21.50n 1.0 21.55n 0 31n 0 31.05n 1.0 31.50n 1.0 31.55n 0]
Vdin1 (din1 0) vsource type=pwl wave=[0 0 7.95n 0 8n 1.0 17.95n 1.0 18n 0 27.95n 0 28n 1.0]
Vdin2 (din2 0) vsource type=pwl wave=[0 0 17.95n 0 18n 1.0]
Vdin3 (din3 0) vsource type=pwl wave=[0 0 7.95n 0 8n 1.0]
Vdin4 (din4 0) vsource type=pwl wave=[0 0 17.95n 0 18n 1.0]

XDUT (din1 din2 din3 din4 rdy aout) l1_dac_4b_bipolar

tran tran stop=40n maxstep=20p
save din1 din2 din3 din4 rdy aout
