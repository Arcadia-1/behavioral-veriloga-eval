simulator lang=spectre
global 0

ahdl_include "duty_cycle_meter_8b.va"

V_clk_in (clk_in 0) vsource type=pulse val0=0 val1=0.9 period=1n delay=100p rise=20p fall=20p width=450p

XDUT (clk_in valid duty0 duty1 duty2 duty3 duty4 duty5 duty6 duty7) duty_cycle_meter_8b

tran tran stop=8n maxstep=100p
save clk_in valid duty0 duty1 duty2 duty3 duty4 duty5 duty6 duty7
