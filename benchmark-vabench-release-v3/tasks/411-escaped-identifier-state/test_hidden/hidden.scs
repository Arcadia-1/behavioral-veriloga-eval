simulator lang=spectre
global 0

ahdl_include "escaped_identifier_state.va"

Vvin (vin 0) vsource type=pwl wave=[0 0.55 100n 0.55 101n 0.25 200n 0.25 201n 0.75 300n 0.75 301n 0.35 420n 0.35]
Vclk (clk 0) vsource type=pwl wave=[0 0.0 49n 0.0 50n 1.0 79n 1.0 80n 0.0 149n 0.0 150n 1.0 179n 1.0 180n 0.0 249n 0.0 250n 1.0 279n 1.0 280n 0.0 349n 0.0 350n 1.0 420n 1.0]
Vmode (mode 0) vsource type=pwl wave=[0 1.0 100n 1.0 101n 0.0 200n 0.0 201n 1.0 300n 1.0 301n 0.0 420n 0.0]
Vrst (rst 0) vsource type=pwl wave=[0 0.0 229n 0.0 230n 0.9 289n 0.9 290n 0.0 420n 0.0]

XDUT (vin clk mode rst out metric) escaped_identifier_state

tran tran stop=420n
save vin clk mode rst out metric
