`include "disciplines.vams"

module reference_settling_window_monitor(clk, rst, ref, target, valid, err_metric, settle_mon);
input clk, rst, ref, target;
output valid, err_metric, settle_mon;
electrical clk, rst, ref, target, valid, err_metric, settle_mon;

parameter real vth = 0.45;
parameter real vhi = 0.9;
parameter real tol = 0.035;
parameter real err_scale = 0.20;
parameter integer settle_cycles = 3;
parameter real tr = 80p;

analog begin
    // Implement instruction.md behavior here.
end
endmodule
