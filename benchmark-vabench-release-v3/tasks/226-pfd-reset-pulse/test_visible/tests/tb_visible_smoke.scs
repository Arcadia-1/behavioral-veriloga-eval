simulator lang=spectre
global 0
ahdl_include "pfd_reset_pulse.va"
Va (a 0) vsource type=pwl wave=[0 0 1n 0 1.02n 0.9 1.30n 0.9 1.32n 0 4n 0 4.02n 0.9 4.30n 0.9 4.32n 0]
Vb (b 0) vsource type=pwl wave=[0 0 1.8n 0 1.82n 0.9 2.10n 0.9 2.12n 0 3.4n 0 3.42n 0.9 3.70n 0.9 3.72n 0]
XDUT (a b ub d) pfd_reset_pulse
tran tran stop=3.6n maxstep=2p
save a b ub d
