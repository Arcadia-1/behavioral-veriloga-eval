`include "disciplines.vams"
module dac_serial_16b_nobridge(clk_sample, clk_sarready, data, out);
input clk_sample, clk_sarready, data;
output out;
electrical clk_sample, clk_sarready, data, out;
analog begin
    V(out) <+ 0.0;
end
endmodule
