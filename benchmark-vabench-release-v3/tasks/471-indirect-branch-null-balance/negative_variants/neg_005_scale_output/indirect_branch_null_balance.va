`include "constants.vams"
`include "disciplines.vams"

module indirect_branch_null_balance (input electrical in, output electrical out);
analog begin
    V(out) : V(out) == 0.5 * V(in);
end
endmodule
