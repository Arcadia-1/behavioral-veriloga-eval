simulator lang=spectre
global 0

ahdl_include "indirect_branch_null_balance.va"

Vin (inp 0) vsource type=pwl wave=[0 0.00 20n 0.00 21n 0.50 60n 0.50 61n 0.20 100n 0.20 101n 0.80 160n 0.80]

XDUT (inp out) indirect_branch_null_balance

tran tran stop=160n
save inp out
