`include "constants.vams"
`include "disciplines.vams"

module indirect_branch_null_balance (
    input  electrical in,
    output electrical out
);
analog begin
    V(out) : V(out) - V(in) == 0;
end
endmodule
