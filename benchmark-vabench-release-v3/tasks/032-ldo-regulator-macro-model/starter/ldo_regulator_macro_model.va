`include "constants.vams"
`include "disciplines.vams"

module ldo_regulator_macro_model(clk, rst, vin, out, metric);
input clk, rst, vin;
output out, metric;
electrical clk, rst, vin, out, metric;
parameter real tr = 100p;
parameter real vth = 0.45;

    // TODO: implement the behavior described in instruction.md.
    // This starter is intentionally incomplete; implement the instruction.md behavior.
endmodule
