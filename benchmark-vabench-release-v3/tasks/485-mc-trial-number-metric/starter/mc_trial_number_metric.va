`include "constants.vams"
`include "disciplines.vams"

module mc_trial_number_metric (
    output electrical out
);
integer trial_num;
analog begin
    @(initial_step) begin
        trial_num = 0;
    end
    V(out) <+ transition(0.0, 0.0, 200p, 200p);
end
endmodule
