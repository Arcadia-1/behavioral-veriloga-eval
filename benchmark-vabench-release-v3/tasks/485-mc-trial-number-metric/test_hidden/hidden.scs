simulator lang=spectre
global 0

ahdl_include "mc_trial_number_metric.va"

Vdummy (stim 0) vsource dc=0.0

XDUT (out) mc_trial_number_metric

tran tran stop=160n
save stim out
