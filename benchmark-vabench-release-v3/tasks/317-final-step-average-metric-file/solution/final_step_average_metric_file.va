`include "constants.vams"
`include "disciplines.vams"

module final_step_average_metric_file (
    input  electrical vin,
    input  electrical clk,
    input  electrical mode,
    input  electrical rst,
    output electrical out,
    output electrical metric
);
parameter real vth = 0.45;
parameter real vhi = 0.9;
parameter real tr = 200p;
real out_v;
real metric_v;
integer count_q;
integer state_q;
integer fd;
real sum_q;
real avg_q;
analog begin
    @(initial_step) begin
        out_v = 0.0;
        metric_v = 0.0;
        count_q = 0;
        state_q = 0;
        sum_q = 0.0;
        avg_q = 0.0;
    end
    @(cross(V(clk) - vth, +1) or cross(V(rst) - vth, +1)) begin
        if (V(rst) > vth) begin
            count_q = 0;
            state_q = 0;
            sum_q = 0.0;
            avg_q = 0.0;
            out_v = 0.0;
            metric_v = 0.0;
        end else begin
            count_q = count_q + 1;
            state_q = count_q;
            sum_q = sum_q + V(vin);
            avg_q = sum_q / count_q;
            out_v = avg_q;
            metric_v = avg_q / vhi;
            if (metric_v > 1.0) metric_v = 1.0;
            if (metric_v < 0.0) metric_v = 0.0;
            $strobe("sample_average count=%0d avg=%g metric=%g", count_q, avg_q, metric_v);
        end
    end
    @(final_step) begin
        fd = $fopen("candidate.out", "w");
        $fwrite(fd, "count=%0d avg=%.3f metric=%.3f", count_q, avg_q, metric_v);
        $fclose(fd);
    end
    V(out) <+ transition(out_v, 0.0, tr, tr);
    V(metric) <+ transition(metric_v, 0.0, tr, tr);
end
endmodule
