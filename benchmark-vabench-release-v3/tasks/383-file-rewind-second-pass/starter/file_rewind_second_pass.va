`include "constants.vams"
`include "disciplines.vams"

module file_rewind_second_pass (
    input  electrical vin,
    input  electrical clk,
    input  electrical mode,
    input  electrical rst,
    output electrical out,
    output electrical metric
);
parameter real vth = 0.45;
parameter real vhi = 0.9;
parameter real tr = 200p;
real out_v;
real metric_v;
integer rewind_hit_q;
integer fd;
string line0;
string line1;
string line_again;
analog begin
    @(initial_step) begin
        out_v = 0.0;
        metric_v = 0.0;
        rewind_hit_q = 0;
        fd = $fopen("config_lines.txt", "r");
        $fgets(line0, fd);
        $fgets(line1, fd);
        $rewind(fd);
        $fgets(line_again, fd);
        $fclose(fd);
        // TODO: set rewind_hit_q and metric_v from the three loaded lines.
    end
    @(cross(V(clk) - vth, +1)) begin
        if (V(rst) > vth) begin
            out_v = 0.0;
        end else begin
            // TODO: gate threshold output by rewind_hit_q.
        end
    end
    V(out) <+ transition(out_v, 0.0, tr, tr);
    V(metric) <+ transition(metric_v, 0.0, tr, tr);
end
endmodule
