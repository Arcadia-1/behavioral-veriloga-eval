simulator lang=spectre
global 0
ahdl_include "reset_sync_active_high.va"
Vclk (clk 0) vsource type=pulse val0=0 val1=0.9 period=10n delay=1n rise=50p fall=50p width=5n
Vrst (rst 0) vsource type=pwl wave=[0 0.9 22n 0.9 22.1n 0 85n 0 85.1n 0.9 105n 0.9 105.1n 0 150n 0]
XDUT (clk rst sync_rst) reset_sync_active_high
tran tran stop=150n maxstep=100p
save clk rst sync_rst
