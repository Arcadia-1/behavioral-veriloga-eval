simulator lang=spectre
global 0

ahdl_include "last_crossing_period_meter.va"

Vvin (vin 0) vsource type=pwl wave=[0 0.1 99n 0.1 100n 0.8 180n 0.8 181n 0.1 299n 0.1 300n 0.8 380n 0.8 381n 0.1 599n 0.1 600n 0.8 680n 0.8 681n 0.1 839n 0.1 840n 0.8 900n 0.8]
Vmode (mode 0) vsource dc=0.0 type=dc
Vrst (rst 0) vsource type=pwl wave=[0 0.0 749n 0.0 750n 0.9 770n 0.9 771n 0.0 900n 0.0]
Vclk (clk 0) vsource dc=0.0 type=dc

XDUT (vin clk mode rst out metric) last_crossing_period_meter

tran tran stop=900n
save vin clk mode rst out metric
