`include "constants.vams"
`include "disciplines.vams"

module last_crossing_period_meter (
    input  electrical vin,
    input  electrical clk,
    input  electrical mode,
    input  electrical rst,
    output electrical out,
    output electrical metric
);
parameter real vth = 0.45;
parameter real vhi = 0.9;
parameter real tr = 200p;
real out_v;
real metric_v;
integer count_q;
integer state_q;
real last_t;
real prev_t;
real period_q;
real lc_q;
real scaled_q;
analog begin
    @(initial_step) begin
        out_v = 0.0;
        metric_v = 0.0;
        count_q = 0;
        state_q = 0;
        last_t = -1.0;
        prev_t = -1.0;
        period_q = 0.0;
        lc_q = -1.0;
        scaled_q = 0.0;
    end
    lc_q = last_crossing(V(vin) - vth, +1, 0.0, 1e-12);
    @(cross(V(vin) - vth, +1, 0.0, 1e-12)) begin
        prev_t = last_t;
        last_t = lc_q;
        count_q = count_q + 1;
        if (prev_t > 0.0) begin
            period_q = last_t - prev_t;
            scaled_q = vhi * period_q / 400e-9;
            if (scaled_q < 0.0) scaled_q = 0.0;
            if (scaled_q > vhi) scaled_q = vhi;
            out_v = scaled_q;
            metric_v = vhi;
        end else begin
            out_v = 0.0;
            metric_v = 0.0;
        end
    end
    @(cross(V(rst) - vth, +1)) begin
        count_q = 0;
        out_v = 0.0;
        metric_v = 0.0;
        last_t = -1.0;
        prev_t = -1.0;
        period_q = 0.0;
        lc_q = -1.0;
        scaled_q = 0.0;
    end
    V(out) <+ transition(out_v, 0.0, tr, tr);
    V(metric) <+ transition(metric_v, 0.0, tr, tr);
end
endmodule
