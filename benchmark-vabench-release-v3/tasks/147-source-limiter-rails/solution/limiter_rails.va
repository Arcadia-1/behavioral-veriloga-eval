`include "disciplines.vams"

module limiter_rails (vdd, vss, vin, vmax, vmin, vout);

input vdd, vss, vin, vmax, vmin;
output vout;
electrical vdd, vss, vin, vmax, vmin, vout;

analog begin
    if (V(vin) > V(vdd) - V(vmax)) begin
        V(vout) <+ V(vdd) - V(vmax);
    end else if (V(vin) < V(vss) + V(vmin)) begin
        V(vout) <+ V(vss) + V(vmin);
    end else begin
        V(vout) <+ V(vin);
    end
end

endmodule
