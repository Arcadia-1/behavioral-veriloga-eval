`include "disciplines.vams"
module tool_4bit_sar_signed_dac(d0, d1, d2, d3, sh, aout);
input d0, d1, d2, d3, sh;
output aout;
electrical d0, d1, d2, d3, sh, aout;
parameter real vth = 0.9;
parameter real gain = 1.8 / 16.0;
parameter real tr = 1p;
analog begin
    V(aout) <+ 0.0;
end
endmodule
