simulator lang=spectre
global 0

ahdl_include "for_loop_running_average.va"

Vvin (vin 0) vsource type=pwl wave=[ 0n 0.2 19n 0.2 20n 0.4 29n 0.4 30n 0.6 39n 0.6 40n 0.8 49n 0.8 50n 0.4 65n 0.4 ]
Vmode (mode 0) vsource type=pwl wave=[ 0n 0 65n 0 ]
Vrst (rst 0) vsource type=pwl wave=[ 0n 0.9 8n 0.9 8.1n 0 65n 0 ]
Vclk (clk 0) vsource type=pwl wave=[ 0n 0 4.9n 0 5.0n 0.9 5.5n 0.9 5.6n 0 14.9n 0 15.0n 0.9 15.5n 0.9 15.6n 0 24.9n 0 25.0n 0.9 25.5n 0.9 25.6n 0 34.9n 0 35.0n 0.9 35.5n 0.9 35.6n 0 44.9n 0 45.0n 0.9 45.5n 0.9 45.6n 0 54.9n 0 55.0n 0.9 55.5n 0.9 55.6n 0 65n 0 ]

XDUT (vin clk mode rst out metric) for_loop_running_average

tran tran stop=65n
save vin clk mode rst out metric
