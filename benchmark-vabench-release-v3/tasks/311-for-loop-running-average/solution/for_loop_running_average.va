`include "constants.vams"
`include "disciplines.vams"

module for_loop_running_average (
    input  electrical vin,
    input  electrical clk,
    input  electrical mode,
    input  electrical rst,
    output electrical out,
    output electrical metric
);
parameter real vth = 0.45;
parameter real vhi = 0.9;
parameter real tr = 200p;
real out_v;
real metric_v;
integer count_q;
integer state_q;
real samples[0:3];
integer i;
real acc;
analog begin
    @(initial_step) begin
        out_v = 0.0;
        metric_v = 0.0;
        count_q = 0;
        state_q = 0;
        for (i = 0; i < 4; i = i + 1) begin
            samples[i] = 0.0;
        end
    end
    @(cross(V(clk) - vth, +1) or cross(V(rst) - vth, +1)) begin
        if (V(rst) > vth) begin
            out_v = 0.0;
            metric_v = 0.0;
            count_q = 0;
            for (i = 0; i < 4; i = i + 1) begin
                samples[i] = 0.0;
            end
        end else begin
            samples[3] = samples[2];
            samples[2] = samples[1];
            samples[1] = samples[0];
            samples[0] = V(vin);
            if (count_q < 4) count_q = count_q + 1;
            acc = 0.0;
            for (i = 0; i < 4; i = i + 1) begin
                acc = acc + samples[i];
            end
            out_v = acc / 4.0;
            metric_v = 0.9 * count_q / 4.0;
        end
    end
    V(out) <+ transition(out_v, 0.0, tr, tr);
    V(metric) <+ transition(metric_v, 0.0, tr, tr);
end
endmodule
