`include "disciplines.vams"

module adc_static_linearity_monitor(vsample, vin, d2, d1, d0, maxerr);
input vsample, vin, d2, d1, d0;
output maxerr;
electrical vsample, vin, d2, d1, d0, maxerr;

analog begin
    V(maxerr) <+ 0.0;
end
endmodule
