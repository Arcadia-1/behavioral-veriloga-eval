`include "constants.vams"
`include "disciplines.vams"
module peak_detector (VDD, VSS, vin, vout);
    inout electrical VDD, VSS;
    input electrical vin;
    output electrical vout;
    analog begin
        V(vout) <+ 0;
    end
endmodule
