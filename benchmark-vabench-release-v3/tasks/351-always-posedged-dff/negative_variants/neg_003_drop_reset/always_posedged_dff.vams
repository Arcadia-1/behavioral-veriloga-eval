module always_posedged_dff(clk, rst, d, en, q);
    input clk, rst, d, en;
    output q;
    logic clk, rst, d, en, q;

    always @(posedge clk) begin q = d; end
endmodule
