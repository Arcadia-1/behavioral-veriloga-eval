`include "constants.vams"
`include "disciplines.vams"

module above_resettable_peak_marker (
    input  electrical vin,
    input  electrical clk,
    input  electrical mode,
    input  electrical rst,
    output electrical out,
    output electrical metric
);
parameter real vth = 0.45;
parameter real vhi = 0.9;
parameter real tr = 200p;
real out_v;
real metric_v;
integer count_q;
integer state_q;
real last_t;
real prev_t;
real period_q;
analog begin
    @(initial_step) begin
        out_v = 0.0;
        metric_v = 0.0;
        count_q = 0;
        state_q = 0;
    end
    @(above(V(vin) - vth)) begin
        state_q = 1;
        out_v = vhi;
    end
    @(cross(V(vin) - vth, +1)) begin
        prev_t = last_t;
        last_t = last_crossing(V(vin) - vth, +1);
        if (prev_t > 0.0) period_q = last_t - prev_t;
        metric_v = period_q * 1.0e9;
    end
    @(cross(V(rst) - vth, +1)) begin
        state_q = 0;
        out_v = 0.0;
        metric_v = 0.0;
    end
    V(out) <+ transition(out_v, 0.0, tr, tr);
    V(metric) <+ transition(metric_v, 0.0, tr, tr);
end
endmodule
