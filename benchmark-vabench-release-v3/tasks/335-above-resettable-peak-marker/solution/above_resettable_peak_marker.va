`include "constants.vams"
`include "disciplines.vams"

module above_resettable_peak_marker (
    input  electrical vin,
    input  electrical clk,
    input  electrical mode,
    input  electrical rst,
    output electrical out,
    output electrical metric
);
parameter real vth = 0.45;
parameter real vhi = 0.9;
parameter real tr = 200p;
real out_v;
real metric_v;
integer count_q;
integer state_q;
real peak_q;
real sample_q;
analog begin
    @(initial_step) begin
        out_v = 0.0;
        metric_v = 0.0;
        count_q = 0;
        state_q = 0;
        peak_q = 0.0;
        sample_q = 0.0;
    end
    @(above(V(vin) - vth)) begin
        state_q = 1;
    end
    @(timer(0, 50n)) begin
        if (state_q != 0) begin
            sample_q = V(vin);
            if (sample_q > peak_q) peak_q = sample_q;
            if (peak_q < 0.0) peak_q = 0.0;
            if (peak_q > vhi) peak_q = vhi;
            metric_v = peak_q;
        end
    end
    @(cross(V(rst) - vth, +1)) begin
        state_q = 0;
        peak_q = 0.0;
        sample_q = 0.0;
        metric_v = 0.0;
    end
    out_v = (state_q != 0) ? vhi : 0.0;
    V(out) <+ transition(out_v, 0.0, tr, tr);
    V(metric) <+ transition(metric_v, 0.0, tr, tr);
end
endmodule
