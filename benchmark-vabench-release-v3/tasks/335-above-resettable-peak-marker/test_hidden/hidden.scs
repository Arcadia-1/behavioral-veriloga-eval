simulator lang=spectre
global 0

ahdl_include "above_resettable_peak_marker.va"

Vvin (vin 0) vsource type=pwl wave=[0 0.1 79n 0.1 80n 0.50 200n 0.50 260n 0.85 350n 0.85 351n 0.25 559n 0.25 560n 0.65 720n 0.65]
Vmode (mode 0) vsource dc=0.0 type=dc
Vrst (rst 0) vsource type=pwl wave=[0 0.0 419n 0.0 420n 0.9 449n 0.9 450n 0.0 720n 0.0]
Vclk (clk 0) vsource dc=0.0 type=dc

XDUT (vin clk mode rst out metric) above_resettable_peak_marker

tran tran stop=720n
save vin clk mode rst out metric
