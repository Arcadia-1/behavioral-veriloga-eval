simulator lang=spectre
global 0
ahdl_include "../solution/specify_specparam_delay.vams"

Va (a 0) vsource type=pulse val0=0 val1=1 period=35n delay=7n rise=100p fall=100p width=13n
Xdut (a y) specify_specparam_delay

tran tran stop=160n
save a y
