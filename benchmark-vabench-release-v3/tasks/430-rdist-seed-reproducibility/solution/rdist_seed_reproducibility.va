`include "constants.vams"
`include "disciplines.vams"

module rdist_seed_reproducibility (
    input  electrical vin,
    input  electrical clk,
    input  electrical mode,
    input  electrical rst,
    output electrical out,
    output electrical metric
);
parameter real vth = 0.45;
parameter real vhi = 0.9;
parameter real tr = 200p;
real out_v;
real metric_v;
integer count_q;
integer seed_a;
integer seed_b;
real rand_a;
real rand_b;
analog begin
    @(initial_step) begin
        out_v = 0.0;
        metric_v = 0.0;
        count_q = 0;
        seed_a = 430;
        seed_b = 430;
    end
    @(cross(V(clk) - vth, +1)) begin
        if (V(rst) > vth) begin
            out_v = 0.0;
            metric_v = 0.0;
            count_q = 0;
        end else begin
            seed_a = 430 + count_q;
            seed_b = 430 + count_q;
            rand_a = $rdist_poisson(seed_a, 2.0);
            rand_b = $rdist_poisson(seed_b, 2.0);
            out_v = V(vin) + 0.01 * rand_a;
            metric_v = 1.0;
            count_q = count_q + 1;
        end
    end
    V(out) <+ transition(out_v, 0.0, tr, tr);
    V(metric) <+ transition(metric_v, 0.0, tr, tr);
end
endmodule
