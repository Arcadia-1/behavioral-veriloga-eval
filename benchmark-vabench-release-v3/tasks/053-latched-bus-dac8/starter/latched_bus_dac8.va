`include "disciplines.vams"

module latched_bus_dac8(vclk, b7, b6, b5, b4, b3, b2, b1, b0, vout);
input vclk, b7, b6, b5, b4, b3, b2, b1, b0;
output vout;
electrical vclk, b7, b6, b5, b4, b3, b2, b1, b0, vout;

analog begin
    V(vout) <+ 0.0;
end
endmodule
