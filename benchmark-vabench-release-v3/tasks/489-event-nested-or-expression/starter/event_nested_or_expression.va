`include "constants.vams"
`include "disciplines.vams"

module event_nested_or_expression (
    input  electrical a,
    input  electrical b,
    output electrical out
);
real q;
analog begin
    @(initial_step) begin
        q = 0.0;
    end
    V(out) <+ transition(q, 0.0, 200p, 200p);
end
endmodule
