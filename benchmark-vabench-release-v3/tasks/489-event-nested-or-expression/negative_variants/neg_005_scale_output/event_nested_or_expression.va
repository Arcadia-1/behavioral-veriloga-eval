`include "constants.vams"
`include "disciplines.vams"

module event_nested_or_expression (input electrical a, input electrical b, output electrical out);
real q;
analog begin
    @(initial_step) q = 0.0;
    @(cross(V(a) - 0.45, +1) or above(V(b) - 0.45) or timer(10n, 20n)) begin
        q = q + 0.1;
        if (q > 0.9) q = 0.0;
    end
    V(out) <+ transition(0.8 * (q), 0.0, 200p, 200p);
end
endmodule
