`include "constants.vams"
`include "disciplines.vams"

module white_noise_voltage_source (
    input  electrical ctrl,
    input  electrical clk,
    output electrical out,
    output electrical metric
);
parameter real vth = 0.45;
parameter real vhi = 0.9;
parameter real tr = 200p;
real metric_v;
analog begin
    @(initial_step) metric_v = 0.0;
    // TODO: add white_noise on out and sample ctrl into metric_v on clk rising crossings.
    V(out) <+ 0.0;
    V(metric) <+ transition(metric_v, 0.0, tr, tr);
end
endmodule
