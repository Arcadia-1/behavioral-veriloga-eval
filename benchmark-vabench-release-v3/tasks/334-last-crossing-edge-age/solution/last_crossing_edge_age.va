`include "constants.vams"
`include "disciplines.vams"

module last_crossing_edge_age (
    input  electrical vin,
    input  electrical clk,
    input  electrical mode,
    input  electrical rst,
    output electrical out,
    output electrical metric
);
parameter real vth = 0.45;
parameter real vhi = 0.9;
parameter real tr = 200p;
real out_v;
real metric_v;
integer count_q;
integer state_q;
real last_t;
real prev_t;
real period_q;
real lc_q;
real age_q;
real scaled_q;
analog begin
    @(initial_step) begin
        out_v = 0.0;
        metric_v = 0.0;
        count_q = 0;
        state_q = 0;
        last_t = -1.0;
        prev_t = -1.0;
        period_q = 0.0;
        lc_q = -1.0;
        age_q = 0.0;
        scaled_q = 0.0;
    end
    lc_q = last_crossing(V(vin) - vth, +1, 0.0, 1e-12);
    @(above(V(vin) - vth)) begin
        state_q = 1;
    end
    @(cross(V(rst) - vth, +1)) begin
        state_q = 0;
        out_v = 0.0;
        metric_v = 0.0;
        last_t = -1.0;
        prev_t = -1.0;
        period_q = 0.0;
        lc_q = -1.0;
        age_q = 0.0;
        scaled_q = 0.0;
    end
    @(timer(0, 50n)) begin
      if (state_q != 0) begin
        age_q = $abstime - lc_q;
        scaled_q = vhi * age_q / 300e-9;
        if (scaled_q < 0.0) scaled_q = 0.0;
        if (scaled_q > vhi) scaled_q = vhi;
        out_v = scaled_q;
        metric_v = (age_q <= 150e-9) ? vhi : 0.0;
      end
    end
    V(out) <+ transition(out_v, 0.0, tr, tr);
    V(metric) <+ transition(metric_v, 0.0, tr, tr);
end
endmodule
