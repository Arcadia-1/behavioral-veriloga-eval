`include "constants.vams"
`include "disciplines.vams"
module clk_burst_gen(CLK, RST_N, CLK_OUT);
    input electrical CLK;
    input electrical RST_N;
    output electrical CLK_OUT;
    analog begin
        V(CLK_OUT) <+ 0;
    end
endmodule
