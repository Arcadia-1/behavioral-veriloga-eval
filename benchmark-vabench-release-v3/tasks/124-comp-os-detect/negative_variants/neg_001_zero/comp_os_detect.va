`include "disciplines.vams"

module comp_os_detect (CLK, DCMPP, VINP, VINN);

output VINP;
output VINN;
electrical CLK, DCMPP, VINP, VINN;

analog begin
    V(VINP) <+ 0;
    V(VINN) <+ 0;
end

endmodule
