`include "disciplines.vams"

module full_adder_logic (vin1, vin2, vin_carry, vout_sum, vout_carry);

input vin1, vin2, vin_carry;
output vout_sum, vout_carry;
electrical vin1, vin2, vin_carry, vout_sum, vout_carry;

analog begin
    V(vout_sum) <+ 0;
    V(vout_carry) <+ 0;
end

endmodule
