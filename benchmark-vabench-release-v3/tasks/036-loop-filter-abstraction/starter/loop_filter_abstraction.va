`include "constants.vams"
`include "disciplines.vams"

module loop_filter_abstraction(clk, rst, vin, out, metric);
input clk, rst, vin;
output out, metric;
electrical clk, rst, vin, out, metric;
parameter real tr = 100p;
parameter real deadband = 0.05;

    // TODO: implement the behavior described in instruction.md.
endmodule
