simulator lang=spectre
global 0

ahdl_include "sar_5bit_serial_decoder.va"

Vclk (clks 0) vsource type=pwl wave=[0 0 1n 0 1.1n 0.9 1.5n 0.9 1.6n 0 16n 0 16.1n 0.9 16.5n 0.9 16.6n 0 32n 0 32.1n 0.9 32.5n 0.9 32.6n 0 36n 0]
Vready (ready 0) vsource type=pwl wave=[0 0 5n 0 5.1n 0.9 5.5n 0.9 5.6n 0 7n 0 7.1n 0.9 7.5n 0.9 7.6n 0 9n 0 9.1n 0.9 9.5n 0.9 9.6n 0 11n 0 11.1n 0.9 11.5n 0.9 11.6n 0 13n 0 13.1n 0.9 13.5n 0.9 13.6n 0 20n 0 20.1n 0.9 20.5n 0.9 20.6n 0 22n 0 22.1n 0.9 22.5n 0.9 22.6n 0 24n 0 24.1n 0.9 24.5n 0.9 24.6n 0 26n 0 26.1n 0.9 26.5n 0.9 26.6n 0 28n 0 28.1n 0.9 28.5n 0.9 28.6n 0 36n 0]
Vdin (din 0) vsource type=pwl wave=[0 0 4n 0.9 6n 0.9 6.1n 0 8n 0 8.1n 0.9 10n 0.9 12n 0.9 12.1n 0 19n 0 21n 0 21.1n 0.9 23n 0.9 23.1n 0 27n 0 27.1n 0.9 36n 0.9]

XDUT (din clks ready dout) sar_5bit_serial_decoder

tran tran stop=35n maxstep=20p
save din clks ready dout
