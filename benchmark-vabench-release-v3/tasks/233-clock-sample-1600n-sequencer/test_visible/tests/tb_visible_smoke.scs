simulator lang=spectre
global 0
ahdl_include "clock_sample_1600n_sequencer.va"
XDUT (rst s nc res conv) clock_sample_1600n_sequencer
tran tran stop=12n maxstep=20p
save rst s nc res conv
