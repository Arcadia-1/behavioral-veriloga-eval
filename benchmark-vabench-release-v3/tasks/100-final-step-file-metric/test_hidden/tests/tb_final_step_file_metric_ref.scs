simulator lang=spectre
global 0

Vvdd (VDD 0) vsource dc=0.9 type=dc
Vvss (VSS 0) vsource dc=0.0 type=dc
Vref (ref 0) vsource type=pulse val0=0 val1=0.9 delay=7n period=15n width=2n rise=50p fall=50p

IDUT (VDD VSS ref metric_out) final_step_file_metric_ref

simulatorOptions options reltol=1e-4 vabstol=1e-6 iabstol=1e-12 temp=27 tnom=27 gmin=1e-12
tran tran stop=100n maxstep=20p errpreset=conservative
save ref metric_out

ahdl_include "./final_step_file_metric_ref.va"
