`include "constants.vams"
`include "disciplines.vams"

module file_feof_line_counter (
    input  electrical vin,
    input  electrical clk,
    input  electrical mode,
    input  electrical rst,
    output electrical out,
    output electrical metric
);
parameter real vth = 0.45;
parameter real vhi = 0.9;
parameter real tr = 200p;
real out_v;
real metric_v;
integer line_count_q;
integer fd;
string line_buf;
analog begin
    @(initial_step) begin
        out_v = 0.0;
        metric_v = 0.0;
        line_count_q = 0;
        fd = $fopen("config_lines.txt", "r");
        while (!$feof(fd) && (line_count_q < 4)) begin
            $fgets(line_buf, fd);
            if (line_buf != "") line_count_q = line_count_q + 1;
        end
        $fclose(fd);
        metric_v = vhi * line_count_q / 2.0;
        if (metric_v < 0.0) metric_v = 0.0;
        else if (metric_v > vhi) metric_v = vhi;
    end
    @(cross(V(clk) - vth, +1)) begin
        if (V(rst) > vth) begin
            out_v = 0.0;
        end else begin
            if ((line_count_q == 2) && (V(vin) > vth)) out_v = vhi;
            else out_v = 0.0;
        end
    end
    V(out) <+ transition(out_v, 0.0, tr, tr);
    V(metric) <+ transition(metric_v, 0.0, tr, tr);
end
endmodule
