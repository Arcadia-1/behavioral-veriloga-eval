`include "constants.vams"
`include "disciplines.vams"

module file_feof_line_counter (
    input  electrical vin,
    input  electrical clk,
    input  electrical mode,
    input  electrical rst,
    output electrical out,
    output electrical metric
);
parameter real vth = 0.45;
parameter real vhi = 0.9;
parameter real tr = 200p;
real out_v;
real metric_v;
integer count_q;
integer state_q;
integer fd;
integer nread;
string line_buf;
analog begin
    @(initial_step) begin
        out_v = 0.0;
        metric_v = 0.0;
        count_q = 0;
        state_q = 0;
        fd = $fopen("config_lines.txt", "r");
        nread = 0;
        while (!$feof(fd) && nread < 2) begin
            nread = nread + $fgets(line_buf, fd);
        end
        $fclose(fd);
        metric_v = nread > 0 ? 1.0 : 0.0;
    end
    @(cross(V(clk) - vth, +1)) begin
        if (V(rst) > vth) begin
            out_v = 0.0;
            metric_v = 0.0;
            count_q = 0;
            state_q = 0;
        end else begin
        count_q = count_q + 1;
        out_v = V(vin) > vth ? vhi : 0.0;
        end
    end
    V(out) <+ transition(out_v, 0.0, tr, tr);
    V(metric) <+ transition(metric_v, 0.0, tr, tr);
end
endmodule
