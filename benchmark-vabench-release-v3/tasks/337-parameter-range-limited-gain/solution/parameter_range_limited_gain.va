`include "constants.vams"
`include "disciplines.vams"

module parameter_range_limited_gain (
    input  electrical vin,
    input  electrical clk,
    input  electrical mode,
    input  electrical rst,
    output electrical out,
    output electrical metric
);
parameter real vth = 0.45;
parameter real vhi = 0.9;
parameter real tr = 200p;
parameter real gain_limited = 1.25 from [0.0:2.0];
real out_v;
real metric_v;
real effective_v;
real raw_v;
integer count_q;
integer state_q;
analog begin
    @(initial_step) begin
        out_v = 0.0;
        metric_v = 0.0;
        count_q = 0;
        state_q = 0;
    end
    @(cross(V(clk) - vth, +1)) begin
        if (V(rst) > vth) begin
            out_v = 0.0;
            metric_v = 0.0;
        end else begin
            effective_v = V(vin);
            if (V(mode) > vth) effective_v = effective_v + 0.20;
            raw_v = gain_limited * effective_v;
            metric_v = raw_v;
            out_v = raw_v;
            if (out_v > vhi) out_v = vhi;
            if (out_v < 0.0) out_v = 0.0;
        end
    end
    V(out) <+ transition(out_v, 0.0, tr, tr);
    V(metric) <+ transition(metric_v, 0.0, tr, tr);
end
endmodule
