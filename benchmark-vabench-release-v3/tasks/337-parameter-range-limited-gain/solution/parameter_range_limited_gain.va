`include "constants.vams"
`include "disciplines.vams"

module parameter_range_limited_gain (
    input  electrical vin,
    input  electrical clk,
    input  electrical mode,
    input  electrical rst,
    output electrical out,
    output electrical metric
);
parameter real vth = 0.45;
parameter real vhi = 0.9;
parameter real tr = 200p;
parameter real gain_limited = 1.25 from [0.0:2.0];
real out_v;
real metric_v;
integer count_q;
integer state_q;
analog begin
    @(initial_step) begin
        out_v = 0.0;
        metric_v = 0.0;
        count_q = 0;
        state_q = 0;
    end
    @(cross(V(clk) - vth, +1)) begin
        out_v = gain_limited * V(vin);
        if (out_v > vhi) out_v = vhi;
        metric_v = gain_limited / 2.0;
    end
    V(out) <+ transition(out_v, 0.0, tr, tr);
    V(metric) <+ transition(metric_v, 0.0, tr, tr);
end
endmodule
