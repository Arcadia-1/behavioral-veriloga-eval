`include "constants.vams"
`include "disciplines.vams"

module task_reset_sequencer (
    input  electrical vin,
    input  electrical clk,
    input  electrical mode,
    input  electrical rst,
    output electrical out,
    output electrical metric
);
parameter real vth = 0.45;
parameter real vhi = 0.9;
parameter real tr = 200p;
real out_v;
real metric_v;
integer phase_q;
task sequence_update;
    input real sample;
    input integer reset_active;
    input integer boost_mode;
    begin
        if (reset_active != 0) begin
            phase_q = 0;
            out_v = 0.0;
            metric_v = 0.0;
        end else begin
            phase_q = phase_q + 1;
            if (boost_mode != 0) out_v = sample + 0.2;
            else out_v = sample;
            if (out_v < 0.0) out_v = 0.0;
            else if (out_v > vhi) out_v = vhi;
            metric_v = phase_q / 4.0;
        end
    end
endtask
analog begin
    @(initial_step) begin
        out_v = 0.0;
        metric_v = 0.0;
        phase_q = 0;
    end
    @(cross(V(clk) - vth, +1)) begin
        sequence_update(V(vin), V(rst) > vth, V(mode) > vth);
    end
    V(out) <+ transition(out_v, 0.0, tr, tr);
    V(metric) <+ transition(metric_v, 0.0, tr, tr);
end
endmodule
