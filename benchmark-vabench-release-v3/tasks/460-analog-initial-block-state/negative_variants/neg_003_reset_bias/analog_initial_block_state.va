`include "constants.vams"
`include "disciplines.vams"

module analog_initial_block_state (input electrical vin, output electrical out);
real init_v;
analog initial begin
    init_v = 0.25;
end
analog begin
    V(out) <+ (V(rst) > 0.45 ? 0.25 : (init_v)) + V(vin);
end
endmodule
