`include "constants.vams"
`include "disciplines.vams"

module analog_initial_block_state (
    input  electrical vin,
    output electrical out
);
real init_v;
analog initial begin
    init_v = 0.0;
end
analog begin
    V(out) <+ V(vin) + init_v;
end
endmodule
