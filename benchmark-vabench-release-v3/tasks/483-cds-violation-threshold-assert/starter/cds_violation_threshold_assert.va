`include "constants.vams"
`include "disciplines.vams"

module cds_violation_threshold_assert (
    input  electrical in,
    output electrical out
);
real out_v;
analog begin
    out_v = V(in);
    V(out) <+ transition(out_v, 0.0, 200p, 200p);
end
endmodule
