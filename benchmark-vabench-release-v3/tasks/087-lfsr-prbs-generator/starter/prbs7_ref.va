`include "constants.vams"
`include "disciplines.vams"

module prbs7_ref (
    input  electrical clk,
    input  electrical rst_n,
    input  electrical en,
    output electrical serial_out,
    output electrical state_0,
    output electrical state_1,
    output electrical state_2,
    output electrical state_3,
    output electrical state_4,
    output electrical state_5,
    output electrical state_6
);

parameter real vdd = 0.9;
parameter real vth = 0.45;
parameter real trf = 10p;
parameter real td  = 0p;
parameter integer seed = 127;

integer state_0_i;
integer state_1_i;
integer state_2_i;
integer state_3_i;
integer state_4_i;
integer state_5_i;
integer state_6_i;
integer feedback;
integer serial_bit;

analog begin
    V(serial_out) <+ transition(0.0, td, trf, trf);
    V(state_0)    <+ transition(0.0, td, trf, trf);
    V(state_1)    <+ transition(0.0, td, trf, trf);
    V(state_2)    <+ transition(0.0, td, trf, trf);
    V(state_3)    <+ transition(0.0, td, trf, trf);
    V(state_4)    <+ transition(0.0, td, trf, trf);
    V(state_5)    <+ transition(0.0, td, trf, trf);
    V(state_6)    <+ transition(0.0, td, trf, trf);
end

endmodule
