`include "constants.vams"
`include "disciplines.vams"

module event_task_function_state_update (
    input  electrical clk,
    input  electrical in,
    output electrical out
);
integer count;
real q;
function real clamp01;
    input real x;
    begin
        clamp01 = x;
    end
endfunction
task update_state;
    input real sample;
    begin
        count = count + 1;
        q = sample;
    end
endtask
analog begin
    @(initial_step) begin
        count = 0;
        q = 0.0;
    end
    @(cross(V(clk) - 0.45, +1)) begin
        update_state(V(in));
    end
    V(out) <+ transition(q, 0.0, 200p, 200p);
end
endmodule
