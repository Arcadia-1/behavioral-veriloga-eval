simulator lang=spectre
global 0

ahdl_include "file_fscanf_multi_column_profile.va"

Vvin (vin 0) vsource dc=0.0
Vclk (clk 0) vsource type=pwl wave=[0 0.0 99n 0.0 100n 1.0 149n 1.0 150n 0.0 199n 0.0 200n 1.0 249n 1.0 250n 0.0 299n 0.0 300n 1.0 349n 1.0 350n 0.0 399n 0.0 400n 1.0 450n 1.0]
Vmode (mode 0) vsource dc=0.0
Vrst (rst 0) vsource type=pwl wave=[0 0.0 149n 0.0 150n 1.0 229n 1.0 230n 0.0 450n 0.0]

XDUT (vin clk mode rst out metric) file_fscanf_multi_column_profile

tran tran stop=450n
save vin clk mode rst out metric
