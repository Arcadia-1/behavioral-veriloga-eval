`include "disciplines.vams"
module dac_restore_7bit_clocked(d6, d5, d4, d3, d2, d1, d0, clk, vout);
input d6, d5, d4, d3, d2, d1, d0, clk;
output vout;
electrical d6, d5, d4, d3, d2, d1, d0, clk, vout;
analog begin
    V(vout) <+ 0.0;
end
endmodule
