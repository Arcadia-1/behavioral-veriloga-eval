`include "disciplines.vams"
module dac_restore_7bit_clocked(d6, d5, d4, d3, d2, d1, d0, clk, vout);
input d6, d5, d4, d3, d2, d1, d0, clk;
output vout;
electrical d6, d5, d4, d3, d2, d1, d0, clk, vout;
parameter real vth = 0.45;
real out_v;
analog begin
    @(cross(V(clk) - vth, +1)) begin
        out_v = (V(d6) > vth ? 64.0 : 0.0) + (V(d5) > vth ? 32.0 : 0.0) + (V(d4) > vth ? 16.0 : 0.0) + (V(d3) > vth ? 8.0 : 0.0) + (V(d2) > vth ? 4.0 : 0.0) + (V(d1) > vth ? 2.0 : 0.0) + (V(d0) > vth ? 1.0 : 0.0);
        out_v = (out_v + 0.5) * 1.8 / 128.0 - 0.9;
    end
    V(vout) <+ transition(out_v, 0, 10p, 10p);
end
endmodule
