`include "constants.vams"
`include "disciplines.vams"

module branch_declaration_voltage_probe (
    input  electrical p,
    input  electrical n,
    output electrical out
);
analog begin
    V(out) <+ transition(0.0, 0.0, 200p, 200p);
end
endmodule
