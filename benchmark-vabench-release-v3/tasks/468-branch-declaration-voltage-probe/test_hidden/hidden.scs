simulator lang=spectre
global 0

ahdl_include "branch_declaration_voltage_probe.va"

Vp (p 0) vsource type=pwl wave=[0 0.20 39n 0.20 40n 0.50 79n 0.50 80n 0.80 119n 0.80 120n 0.05 160n 0.05]
Vn (n 0) vsource dc=0.10

XDUT (p n out) branch_declaration_voltage_probe

tran tran stop=160n
save p n out
