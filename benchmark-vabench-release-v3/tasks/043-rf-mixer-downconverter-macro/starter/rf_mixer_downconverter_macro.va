`include "constants.vams"
`include "disciplines.vams"

module rf_mixer_downconverter_macro(clk, rst, vin, out, metric);
input clk, rst, vin;
output out, metric;
electrical clk, rst, vin, out, metric;
parameter real tr = 80p;
parameter real vth = 0.45;
parameter real conv_gain = 1.25;

analog begin
    V(out) <+ transition(0.45, 0, tr, tr);
    V(metric) <+ transition(0.0, 0, tr, tr);
end

endmodule
