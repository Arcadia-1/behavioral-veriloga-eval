// vaBench generated partial-pass negative: reset_polarity_wrong
// Preserves module/interface shape while intentionally violating one hidden behavior contract.
`include "constants.vams"
`include "disciplines.vams"
`default_transition 30p

module dither_adder(
    input  electrical VRES_P,
    input  electrical VRES_N,
    input  electrical DPN,
    output electrical VOUT_P,
    output electrical VOUT_N
);

parameter real vdd        = 0.9;
parameter real vth        = 0.45;
parameter real DITHER_AMP = 0.014063;

real dither_diff;

analog begin
    @(initial_step)
        $strobe("[dither_adder] INIT | DITHER_AMP=%.4fmV", DITHER_AMP*1e3);

    dither_diff = (V(DPN) > vth) ? DITHER_AMP : -DITHER_AMP;

    V(VOUT_P) <+ (0.42 * (V(VRES_P) + dither_diff * 0.5));
    V(VOUT_N) <+ V(VRES_N) - dither_diff * 0.5;
end

endmodule
