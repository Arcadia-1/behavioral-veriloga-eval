`include "constants.vams"
`include "disciplines.vams"

module bound_step_clock_guard (
    input  electrical vin,
    input  electrical clk,
    input  electrical mode,
    input  electrical rst,
    output electrical out,
    output electrical metric
);
parameter real vth = 0.45;
parameter real vhi = 0.9;
parameter real tr = 200p;
real out_v;
real metric_v;
integer count_q;
integer state_q;
analog begin
    @(initial_step) begin
        out_v = 0.0;
        metric_v = 0.0;
        count_q = 0;
        state_q = 0;
    end
    $bound_step(0.5n);
    @(cross(V(clk) - vth, +1)) begin
        if (V(rst) > vth) begin
            out_v = 0.0;
            metric_v = 0.0;
        end else if (V(mode) > vth) begin
            out_v = V(vin);
            if (out_v > vhi) out_v = vhi;
            if (out_v < 0.0) out_v = 0.0;
            metric_v = 0.8;
        end else begin
            metric_v = 0.2;
        end
    end
    V(out) <+ transition(out_v, 0.0, tr, tr);
    V(metric) <+ transition(metric_v, 0.0, tr, tr);
end
endmodule
