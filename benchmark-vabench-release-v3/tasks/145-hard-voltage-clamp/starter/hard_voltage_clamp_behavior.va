`include "disciplines.vams"

module hard_voltage_clamp_behavior (vin, vout, vgnd);

input vin, vgnd;
output vout;
electrical vin, vout, vgnd;

parameter real vclamp_upper = 1;
parameter real vclamp_lower = 0;

analog begin
    V(vout, vgnd) <+ 0;
end

endmodule
