`include "constants.vams"
`include "disciplines.vams"
module file_metric_writer(vin, done);
    input electrical vin;
    output electrical done;
    analog begin
        V(done) <+ 0;
    end
endmodule
