simulator lang=spectre
global 0
tran tran stop=160n
save vin clk mode rst out metric
