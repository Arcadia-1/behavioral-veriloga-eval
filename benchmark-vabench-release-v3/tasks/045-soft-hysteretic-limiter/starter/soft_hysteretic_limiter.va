`include "constants.vams"
`include "disciplines.vams"

module soft_hysteretic_limiter(clk, rst, vin, out, metric);
input clk, rst, vin;
output out, metric;
electrical clk, rst, vin, out, metric;
parameter real tr = 100p;
parameter real gain = 1.8;
parameter real hys_step = 0.08;

analog begin
    // Benign placeholder so the public smoke deck has driven observable nodes.
    V(out) <+ transition(0.45, 0, tr, tr);
    V(metric) <+ transition(0.45, 0, tr, tr);
end
endmodule
