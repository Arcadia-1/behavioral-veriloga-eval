`include "constants.vams"
`include "disciplines.vams"

// Comparator with regeneration-delay parameters exposed as public model controls.
module cmp_delay (
    input  electrical CLK,
    input  electrical VINN,
    input  electrical VINP,
    output electrical DCMPN,
    output electrical DCMPP,
    output electrical LP,
    output electrical LM,
    inout  electrical VSS,
    inout  electrical VDD
);

parameter real voffset = 0.0;
parameter real tau     = 4.34e-12;   // regeneration time constant [s]
parameter real td_0    = 20.5e-12;   // base delay offset [s]
parameter real td_min  = 20e-12;     // minimum delay floor [s]
parameter real td_max  = 200e-12;    // maximum delay ceiling [s]

    // TODO: implement the behavior described in instruction.md.
endmodule
