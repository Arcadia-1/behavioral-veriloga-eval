`include "constants.vams"
`include "disciplines.vams"

module for_loop_thermometer_count (
    input  electrical vin,
    input  electrical clk,
    input  electrical mode,
    input  electrical rst,
    output electrical out,
    output electrical metric
);
parameter real vth = 0.45;
parameter real vhi = 0.9;
parameter real tr = 200p;
real out_v;
real metric_v;
integer count_q;
integer state_q;
real thresholds[0:3];
integer i;
analog begin
    @(initial_step) begin
        out_v = 0.0;
        metric_v = 0.0;
        count_q = 0;
        state_q = 0;
        thresholds[0] = 0.18;
        thresholds[1] = 0.36;
        thresholds[2] = 0.54;
        thresholds[3] = 0.72;
    end
    @(cross(V(clk) - vth, +1) or cross(V(rst) - vth, +1)) begin
        if (V(rst) > vth) begin
            count_q = 0;
            out_v = 0.0;
            metric_v = 0.0;
        end else begin
            count_q = 0;
            for (i = 0; i < 4; i = i + 1) begin
                if (V(vin) > thresholds[i]) count_q = count_q + 1;
            end
            out_v = 0.9 * count_q / 4.0;
            metric_v = count_q / 4.0;
        end
    end
    V(out) <+ transition(out_v, 0.0, tr, tr);
    V(metric) <+ transition(metric_v, 0.0, tr, tr);
end
endmodule
