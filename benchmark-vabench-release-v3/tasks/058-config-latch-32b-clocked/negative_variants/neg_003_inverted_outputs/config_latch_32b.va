`include "constants.vams"
`include "disciplines.vams"

module config_latch_32b(
    en,
    d31,
    d30,
    d29,
    d28,
    d27,
    d26,
    d25,
    d24,
    d23,
    d22,
    d21,
    d20,
    d19,
    d18,
    d17,
    d16,
    d15,
    d14,
    d13,
    d12,
    d11,
    d10,
    d9,
    d8,
    d7,
    d6,
    d5,
    d4,
    d3,
    d2,
    d1,
    d0,
    q31,
    q30,
    q29,
    q28,
    q27,
    q26,
    q25,
    q24,
    q23,
    q22,
    q21,
    q20,
    q19,
    q18,
    q17,
    q16,
    q15,
    q14,
    q13,
    q12,
    q11,
    q10,
    q9,
    q8,
    q7,
    q6,
    q5,
    q4,
    q3,
    q2,
    q1,
    q0
);
    input en, d31, d30, d29, d28, d27, d26, d25, d24, d23, d22, d21, d20, d19, d18, d17, d16, d15, d14, d13, d12, d11, d10, d9, d8, d7, d6, d5, d4, d3, d2, d1, d0;
    output q31, q30, q29, q28, q27, q26, q25, q24, q23, q22, q21, q20, q19, q18, q17, q16, q15, q14, q13, q12, q11, q10, q9, q8, q7, q6, q5, q4, q3, q2, q1, q0;
    electrical en, d31, d30, d29, d28, d27, d26, d25, d24, d23, d22, d21, d20, d19, d18, d17, d16, d15, d14, d13, d12, d11, d10, d9, d8, d7, d6, d5, d4, d3, d2, d1, d0, q31, q30, q29, q28, q27, q26, q25, q24, q23, q22, q21, q20, q19, q18, q17, q16, q15, q14, q13, q12, q11, q10, q9, q8, q7, q6, q5, q4, q3, q2, q1, q0;
    parameter real vdd = 0.9;
    parameter real vth = 0.45;
    parameter real tr = 20p;
    analog begin
        V(q0) <+ transition((V(en) > vth && V(d0) > vth) ? 0.0 : vdd, 0, tr, tr);
        V(q1) <+ transition((V(en) > vth && V(d1) > vth) ? 0.0 : vdd, 0, tr, tr);
        V(q2) <+ transition((V(en) > vth && V(d2) > vth) ? 0.0 : vdd, 0, tr, tr);
        V(q3) <+ transition((V(en) > vth && V(d3) > vth) ? 0.0 : vdd, 0, tr, tr);
        V(q4) <+ transition((V(en) > vth && V(d4) > vth) ? 0.0 : vdd, 0, tr, tr);
        V(q5) <+ transition((V(en) > vth && V(d5) > vth) ? 0.0 : vdd, 0, tr, tr);
        V(q6) <+ transition((V(en) > vth && V(d6) > vth) ? 0.0 : vdd, 0, tr, tr);
        V(q7) <+ transition((V(en) > vth && V(d7) > vth) ? 0.0 : vdd, 0, tr, tr);
        V(q8) <+ transition((V(en) > vth && V(d8) > vth) ? 0.0 : vdd, 0, tr, tr);
        V(q9) <+ transition((V(en) > vth && V(d9) > vth) ? 0.0 : vdd, 0, tr, tr);
        V(q10) <+ transition((V(en) > vth && V(d10) > vth) ? 0.0 : vdd, 0, tr, tr);
        V(q11) <+ transition((V(en) > vth && V(d11) > vth) ? 0.0 : vdd, 0, tr, tr);
        V(q12) <+ transition((V(en) > vth && V(d12) > vth) ? 0.0 : vdd, 0, tr, tr);
        V(q13) <+ transition((V(en) > vth && V(d13) > vth) ? 0.0 : vdd, 0, tr, tr);
        V(q14) <+ transition((V(en) > vth && V(d14) > vth) ? 0.0 : vdd, 0, tr, tr);
        V(q15) <+ transition((V(en) > vth && V(d15) > vth) ? 0.0 : vdd, 0, tr, tr);
        V(q16) <+ transition((V(en) > vth && V(d16) > vth) ? 0.0 : vdd, 0, tr, tr);
        V(q17) <+ transition((V(en) > vth && V(d17) > vth) ? 0.0 : vdd, 0, tr, tr);
        V(q18) <+ transition((V(en) > vth && V(d18) > vth) ? 0.0 : vdd, 0, tr, tr);
        V(q19) <+ transition((V(en) > vth && V(d19) > vth) ? 0.0 : vdd, 0, tr, tr);
        V(q20) <+ transition((V(en) > vth && V(d20) > vth) ? 0.0 : vdd, 0, tr, tr);
        V(q21) <+ transition((V(en) > vth && V(d21) > vth) ? 0.0 : vdd, 0, tr, tr);
        V(q22) <+ transition((V(en) > vth && V(d22) > vth) ? 0.0 : vdd, 0, tr, tr);
        V(q23) <+ transition((V(en) > vth && V(d23) > vth) ? 0.0 : vdd, 0, tr, tr);
        V(q24) <+ transition((V(en) > vth && V(d24) > vth) ? 0.0 : vdd, 0, tr, tr);
        V(q25) <+ transition((V(en) > vth && V(d25) > vth) ? 0.0 : vdd, 0, tr, tr);
        V(q26) <+ transition((V(en) > vth && V(d26) > vth) ? 0.0 : vdd, 0, tr, tr);
        V(q27) <+ transition((V(en) > vth && V(d27) > vth) ? 0.0 : vdd, 0, tr, tr);
        V(q28) <+ transition((V(en) > vth && V(d28) > vth) ? 0.0 : vdd, 0, tr, tr);
        V(q29) <+ transition((V(en) > vth && V(d29) > vth) ? 0.0 : vdd, 0, tr, tr);
        V(q30) <+ transition((V(en) > vth && V(d30) > vth) ? 0.0 : vdd, 0, tr, tr);
        V(q31) <+ transition((V(en) > vth && V(d31) > vth) ? 0.0 : vdd, 0, tr, tr);
    end
endmodule
