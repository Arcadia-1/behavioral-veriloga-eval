`include "constants.vams"
`include "disciplines.vams"

module config_latch_32b(
    en,
    d31,
    d30,
    d29,
    d28,
    d27,
    d26,
    d25,
    d24,
    d23,
    d22,
    d21,
    d20,
    d19,
    d18,
    d17,
    d16,
    d15,
    d14,
    d13,
    d12,
    d11,
    d10,
    d9,
    d8,
    d7,
    d6,
    d5,
    d4,
    d3,
    d2,
    d1,
    d0,
    q31,
    q30,
    q29,
    q28,
    q27,
    q26,
    q25,
    q24,
    q23,
    q22,
    q21,
    q20,
    q19,
    q18,
    q17,
    q16,
    q15,
    q14,
    q13,
    q12,
    q11,
    q10,
    q9,
    q8,
    q7,
    q6,
    q5,
    q4,
    q3,
    q2,
    q1,
    q0
);
    input en, d31, d30, d29, d28, d27, d26, d25, d24, d23, d22, d21, d20, d19, d18, d17, d16, d15, d14, d13, d12, d11, d10, d9, d8, d7, d6, d5, d4, d3, d2, d1, d0;
    output q31, q30, q29, q28, q27, q26, q25, q24, q23, q22, q21, q20, q19, q18, q17, q16, q15, q14, q13, q12, q11, q10, q9, q8, q7, q6, q5, q4, q3, q2, q1, q0;
    electrical en, d31, d30, d29, d28, d27, d26, d25, d24, d23, d22, d21, d20, d19, d18, d17, d16, d15, d14, d13, d12, d11, d10, d9, d8, d7, d6, d5, d4, d3, d2, d1, d0, q31, q30, q29, q28, q27, q26, q25, q24, q23, q22, q21, q20, q19, q18, q17, q16, q15, q14, q13, q12, q11, q10, q9, q8, q7, q6, q5, q4, q3, q2, q1, q0;
    parameter real vdd = 0.9;
    parameter real vth = 0.45;
    parameter real tr = 20p;
    analog begin
        V(q0) <+ transition((V(d0) > vth) ? vdd : 0.0, 0, tr, tr);
        V(q1) <+ transition((V(d1) > vth) ? vdd : 0.0, 0, tr, tr);
        V(q2) <+ transition((V(d2) > vth) ? vdd : 0.0, 0, tr, tr);
        V(q3) <+ transition((V(d3) > vth) ? vdd : 0.0, 0, tr, tr);
        V(q4) <+ transition((V(d4) > vth) ? vdd : 0.0, 0, tr, tr);
        V(q5) <+ transition((V(d5) > vth) ? vdd : 0.0, 0, tr, tr);
        V(q6) <+ transition((V(d6) > vth) ? vdd : 0.0, 0, tr, tr);
        V(q7) <+ transition((V(d7) > vth) ? vdd : 0.0, 0, tr, tr);
        V(q8) <+ transition((V(d8) > vth) ? vdd : 0.0, 0, tr, tr);
        V(q9) <+ transition((V(d9) > vth) ? vdd : 0.0, 0, tr, tr);
        V(q10) <+ transition((V(d10) > vth) ? vdd : 0.0, 0, tr, tr);
        V(q11) <+ transition((V(d11) > vth) ? vdd : 0.0, 0, tr, tr);
        V(q12) <+ transition((V(d12) > vth) ? vdd : 0.0, 0, tr, tr);
        V(q13) <+ transition((V(d13) > vth) ? vdd : 0.0, 0, tr, tr);
        V(q14) <+ transition((V(d14) > vth) ? vdd : 0.0, 0, tr, tr);
        V(q15) <+ transition((V(d15) > vth) ? vdd : 0.0, 0, tr, tr);
        V(q16) <+ transition((V(d16) > vth) ? vdd : 0.0, 0, tr, tr);
        V(q17) <+ transition((V(d17) > vth) ? vdd : 0.0, 0, tr, tr);
        V(q18) <+ transition((V(d18) > vth) ? vdd : 0.0, 0, tr, tr);
        V(q19) <+ transition((V(d19) > vth) ? vdd : 0.0, 0, tr, tr);
        V(q20) <+ transition((V(d20) > vth) ? vdd : 0.0, 0, tr, tr);
        V(q21) <+ transition((V(d21) > vth) ? vdd : 0.0, 0, tr, tr);
        V(q22) <+ transition((V(d22) > vth) ? vdd : 0.0, 0, tr, tr);
        V(q23) <+ transition((V(d23) > vth) ? vdd : 0.0, 0, tr, tr);
        V(q24) <+ transition((V(d24) > vth) ? vdd : 0.0, 0, tr, tr);
        V(q25) <+ transition((V(d25) > vth) ? vdd : 0.0, 0, tr, tr);
        V(q26) <+ transition((V(d26) > vth) ? vdd : 0.0, 0, tr, tr);
        V(q27) <+ transition((V(d27) > vth) ? vdd : 0.0, 0, tr, tr);
        V(q28) <+ transition((V(d28) > vth) ? vdd : 0.0, 0, tr, tr);
        V(q29) <+ transition((V(d29) > vth) ? vdd : 0.0, 0, tr, tr);
        V(q30) <+ transition((V(d30) > vth) ? vdd : 0.0, 0, tr, tr);
        V(q31) <+ transition((V(d31) > vth) ? vdd : 0.0, 0, tr, tr);
    end
endmodule
