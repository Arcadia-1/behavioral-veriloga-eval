`include "disciplines.vams"
module lt_read_sar6b_weighted(d0, d1, d2, d3, d4, d5, vout, gnd);
input d0, d1, d2, d3, d4, d5, gnd;
output vout;
electrical d0, d1, d2, d3, d4, d5, vout, gnd;
analog begin
    V(vout) <+ 0.0;
end
endmodule
