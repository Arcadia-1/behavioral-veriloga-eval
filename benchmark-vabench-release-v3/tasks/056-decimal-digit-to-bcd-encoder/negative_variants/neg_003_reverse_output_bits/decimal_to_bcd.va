`include "constants.vams"
`include "disciplines.vams"

module decimal_to_bcd(
    d9,
    d8,
    d7,
    d6,
    d5,
    d4,
    d3,
    d2,
    d1,
    d0,
    b3,
    b2,
    b1,
    b0,
    valid
);
    input d9, d8, d7, d6, d5, d4, d3, d2, d1, d0;
    output b3, b2, b1, b0, valid;
    electrical d9, d8, d7, d6, d5, d4, d3, d2, d1, d0, b3, b2, b1, b0, valid;
    parameter real vdd = 0.9;
    parameter real vth = 0.45;
    parameter real tr = 20p;
    analog begin
        V(b3) <+ transition(V(d0) > vth ? vdd : 0.0, 0, tr, tr);
        V(b2) <+ transition(0.0, 0, tr, tr);
        V(b1) <+ transition(0.0, 0, tr, tr);
        V(b0) <+ transition(0.0, 0, tr, tr);
        V(valid) <+ transition(0.0, 0, tr, tr);
    end
endmodule
