`include "constants.vams"
`include "disciplines.vams"

module decimal_to_bcd(
    input electrical [9:0] d,
    output electrical [3:0] b,
    output electrical valid
);
    parameter real vdd = 0.9;
    parameter real vth = 0.45;
    parameter real tr = 20p;
    genvar i;
    analog begin
        for (i = 0; i < 4; i = i + 1) V(b[i]) <+ transition(0.0, 0, tr, tr);
        V(valid) <+ transition(0.0, 0, tr, tr);
    end
endmodule
