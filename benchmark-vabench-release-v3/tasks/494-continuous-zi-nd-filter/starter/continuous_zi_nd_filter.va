`include "constants.vams"
`include "disciplines.vams"

module continuous_zi_nd_filter (
    input  electrical in,
    output electrical out
);
analog begin
    V(out) <+ zi_nd(V(in), {0.5, 0.5}, {1.0, -0.25}, 10n);
end
endmodule
