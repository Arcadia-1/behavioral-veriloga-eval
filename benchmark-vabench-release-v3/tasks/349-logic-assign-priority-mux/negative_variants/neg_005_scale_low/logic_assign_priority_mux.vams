module logic_assign_priority_mux(a, b, en, y);
    input a, b, en;
    output y;
    logic a, b, en, y;
    assign y = (en ? a : b) & (b & !b);
endmodule
