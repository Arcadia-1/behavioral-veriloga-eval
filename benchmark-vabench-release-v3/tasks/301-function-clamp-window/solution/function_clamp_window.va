`include "constants.vams"
`include "disciplines.vams"

module function_clamp_window (
    input  electrical vin,
    input  electrical clk,
    input  electrical mode,
    input  electrical rst,
    output electrical out,
    output electrical metric
);
parameter real vth = 0.45;
parameter real vhi = 0.9;
parameter real tr = 200p;
real out_v;
real metric_v;
integer count_q;
integer state_q;
analog function real clamp_window;
    input x;
    real x;
    begin
        if (x < 0.1) clamp_window = 0.1;
        else if (x > 0.8) clamp_window = 0.8;
        else clamp_window = x;
    end
endfunction
analog begin
    @(initial_step) begin
        out_v = 0.0;
        metric_v = 0.0;
        count_q = 0;
        state_q = 0;
    end
    @(cross(V(clk) - vth, +1)) begin
        out_v = clamp_window(V(vin));
        metric_v = out_v / vhi;
    end
    V(out) <+ transition(out_v, 0.0, tr, tr);
    V(metric) <+ transition(metric_v, 0.0, tr, tr);
end
endmodule
