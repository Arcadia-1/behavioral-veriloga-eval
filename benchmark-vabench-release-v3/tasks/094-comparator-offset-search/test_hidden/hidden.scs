simulator lang=spectre
global 0

Vvdd (vdd 0) vsource dc=0.9
Vvss (vss 0) vsource dc=0.0
Vinn (inn 0) vsource dc=0.47
Vinp (inp 0) vsource type=pwl wave=[ \
    0    0.462 \
    110n 0.490 \
    130n 0.490 \
]

XDUT (vdd vss inp inn outp trip_v offset_est valid) comparator_offset_search_ref

tran tran stop=130n maxstep=50p errpreset=conservative
save inp inn outp trip_v offset_est valid

ahdl_include "comparator_offset_search_ref.va"
