`include "constants.vams"
`include "disciplines.vams"

module combined_white_flicker_noise (
    input  electrical ctrl,
    input  electrical clk,
    output electrical out,
    output electrical metric
);
parameter real vth = 0.45;
parameter real vhi = 0.9;
parameter real tr = 200p;
real metric_v;
analog begin
    @(initial_step) metric_v = 0.0;
    // TODO: combine white_noise and flicker_noise on out, then report the parameter sum.
    V(out) <+ 0.0;
    V(metric) <+ transition(metric_v, 0.0, tr, tr);
end
endmodule
