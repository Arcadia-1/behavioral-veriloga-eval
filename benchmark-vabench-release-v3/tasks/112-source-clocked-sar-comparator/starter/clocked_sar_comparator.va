`include "constants.vams"
`include "disciplines.vams"

module clocked_sar_comparator(CMPCK, VINN, VINP, DCMPN, DCMPP);
    input CMPCK, VINN, VINP;
    output DCMPN, DCMPP;
    electrical CMPCK, VINN, VINP, DCMPN, DCMPP;

    parameter real vdd = 0.9;
    parameter real td_cmp = 20p;
    parameter real tr = 5p;

    // TODO: implement the clocked comparator behavior.
endmodule
