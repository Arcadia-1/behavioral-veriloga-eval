simulator lang=spectre
global 0

ahdl_include "port_connected_output_enable.va"

Vvin (vin 0) vsource type=pwl wave=[0 0.60 40n 0.60 41n 0.30 80n 0.30 81n 0.80 160n 0.80]
Vclk (clk 0) vsource type=pwl wave=[0 0.0 9n 0.0 10n 1.0 14n 1.0 15n 0.0 49n 0.0 50n 1.0 54n 1.0 55n 0.0 69n 0.0 70n 1.0 74n 1.0 75n 0.0 89n 0.0 90n 1.0 94n 1.0 95n 0.0 129n 0.0 130n 1.0 134n 1.0 135n 0.0 160n 0.0]
Vmode (mode 0) vsource dc=0.0
Vrst (rst 0) vsource type=pwl wave=[0 0.0 59n 0.0 60n 1.0 79n 1.0 80n 0.0 160n 0.0]

XDUT (vin clk mode rst metric out) port_connected_output_enable

tran tran stop=160n
save vin clk mode rst out metric
