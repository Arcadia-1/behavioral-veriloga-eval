`include "constants.vams"
`include "disciplines.vams"

module port_connected_output_enable (
    input  electrical vin,
    input  electrical clk,
    input  electrical mode,
    input  electrical rst,
    output electrical metric,
    output electrical out
);
parameter real vth = 0.45;
parameter real vhi = 0.9;
parameter real tr = 200p;
real out_v;
real metric_v;
real port_present;
integer count_q;
analog begin
    if ($port_connected(out)) begin
        port_present = 1.0;
    end else begin
        port_present = 0.0;
    end
    @(initial_step) begin
        out_v = 0.0;
        metric_v = 0.0;
        port_present = 0.0;
        count_q = 0;
    end
    @(cross(V(clk) - vth, +1)) begin
        if (V(rst) > vth) begin
            out_v = 0.0;
            metric_v = 0.0;
            count_q = 0;
        end else begin
            out_v = V(vin);
            metric_v = 1.0;
            count_q = count_q + 1;
        end
    end
    V(out) <+ transition(port_present * out_v, 0.0, tr, tr);
    V(metric) <+ transition(port_present * metric_v, 0.0, tr, tr);
end
endmodule
