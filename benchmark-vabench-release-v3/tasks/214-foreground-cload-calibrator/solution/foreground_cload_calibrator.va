`include "disciplines.vams"

module foreground_cload_calibrator(ck, d, vrefp, vrefn, dcp0, dcp1, dcp2, dcp3, dcp4, dcn0, dcn1, dcn2, dcn3, dcn4, cvinp, cvinn, en, enb);
input ck, d, vrefp, vrefn;
output dcp0, dcp1, dcp2, dcp3, dcp4, dcn0, dcn1, dcn2, dcn3, dcn4, cvinp, cvinn, en, enb;
electrical ck, d, vrefp, vrefn, dcp0, dcp1, dcp2, dcp3, dcp4, dcn0, dcn1, dcn2, dcn3, dcn4, cvinp, cvinn, en, enb;

parameter real vdd = 1.0;
integer iter;
integer flag_calib;
integer dp0, dp1, dp2, dp3, dp4;
integer dn0, dn1, dn2, dn3, dn4;

analog begin
    @(initial_step) begin
        iter = 4;
        flag_calib = 1;
        dp0 = 0; dp1 = 0; dp2 = 0; dp3 = 0; dp4 = 0;
        dn0 = 0; dn1 = 0; dn2 = 0; dn3 = 0; dn4 = 0;
    end
    @(cross(V(ck) - 0.5 * vdd, +1)) begin
        if (iter > -1) begin
            if (iter == 4) begin
                if (V(d) < 0.5 * vdd) begin dp4 = 1; dn4 = 0; end
                else begin dp4 = 0; dn4 = 1; end
            end else if (iter == 3) begin
                if (V(d) < 0.5 * vdd) begin dp3 = 1; dn3 = 0; end
                else begin dp3 = 0; dn3 = 1; end
            end else if (iter == 2) begin
                if (V(d) < 0.5 * vdd) begin dp2 = 1; dn2 = 0; end
                else begin dp2 = 0; dn2 = 1; end
            end else if (iter == 1) begin
                if (V(d) < 0.5 * vdd) begin dp1 = 1; dn1 = 0; end
                else begin dp1 = 0; dn1 = 1; end
            end else begin
                if (V(d) < 0.5 * vdd) begin dp0 = 1; dn0 = 0; end
                else begin dp0 = 0; dn0 = 1; end
            end
            iter = iter - 1;
        end else begin
            flag_calib = 0;
        end
    end
    V(cvinp) <+ V(vrefp);
    V(cvinn) <+ V(vrefn);
    V(en) <+ transition(flag_calib ? vdd : 0.0, 0, 20p, 20p);
    V(enb) <+ transition(flag_calib ? 0.0 : vdd, 0, 20p, 20p);
    V(dcp0) <+ transition(dp0 ? vdd : 0.0, 0, 20p, 20p);
    V(dcp1) <+ transition(dp1 ? vdd : 0.0, 0, 20p, 20p);
    V(dcp2) <+ transition(dp2 ? vdd : 0.0, 0, 20p, 20p);
    V(dcp3) <+ transition(dp3 ? vdd : 0.0, 0, 20p, 20p);
    V(dcp4) <+ transition(dp4 ? vdd : 0.0, 0, 20p, 20p);
    V(dcn0) <+ transition(dn0 ? vdd : 0.0, 0, 20p, 20p);
    V(dcn1) <+ transition(dn1 ? vdd : 0.0, 0, 20p, 20p);
    V(dcn2) <+ transition(dn2 ? vdd : 0.0, 0, 20p, 20p);
    V(dcn3) <+ transition(dn3 ? vdd : 0.0, 0, 20p, 20p);
    V(dcn4) <+ transition(dn4 ? vdd : 0.0, 0, 20p, 20p);
end

endmodule
