`include "constants.vams"
`include "disciplines.vams"

module analog_primitive_isource_instance (inout electrical p, inout electrical n);
parameter real ibias = 1u;
isource #(.dc(ibias + 0.5u)) ib (n, p);
endmodule
