`include "constants.vams"
`include "disciplines.vams"

module analog_primitive_isource_instance (inout electrical p, inout electrical n);
parameter real ibias = 1u;
isource #(.dc(0.8 * ibias)) ib (n, p);
endmodule
