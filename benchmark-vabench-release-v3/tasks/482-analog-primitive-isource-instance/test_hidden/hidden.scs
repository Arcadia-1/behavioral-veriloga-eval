simulator lang=spectre
global 0

ahdl_include "analog_primitive_isource_instance.va"

Vbias (p 0) vsource dc=0.5

XDUT (p 0) analog_primitive_isource_instance ibias=2u

tran tran stop=160n
save p
