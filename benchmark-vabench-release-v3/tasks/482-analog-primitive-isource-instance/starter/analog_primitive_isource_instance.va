`include "constants.vams"
`include "disciplines.vams"

module analog_primitive_isource_instance (
    inout electrical p,
    inout electrical n
);
parameter real ibias = 1u;
isource #(.dc(ibias)) ib (n, p);
endmodule
