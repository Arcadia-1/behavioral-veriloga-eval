`include "disciplines.vams"
module limiting_diffamp(sigin_p, sigin_n, sigout);
input sigin_p, sigin_n; output sigout; electrical sigin_p, sigin_n, sigout; parameter real gain=4.0;
analog begin V(sigout) <+ gain * V(sigin_p,sigin_n); end
endmodule
