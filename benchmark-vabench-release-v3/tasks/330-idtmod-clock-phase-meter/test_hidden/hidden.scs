simulator lang=spectre
global 0

ahdl_include "idtmod_clock_phase_meter.va"

Vvin (vin 0) vsource type=pwl wave=[0 0.20 249n 0.20 250n 0.65 549n 0.65 550n 0.35 780n 0.35]
Vmode (mode 0) vsource dc=0.55 type=dc
Vrst (rst 0) vsource dc=0.0 type=dc
Vclk (clk 0) vsource type=pwl wave=[0 0.0 119n 0.0 120n 0.9 145n 0.9 146n 0.0 279n 0.0 280n 0.9 305n 0.9 306n 0.0 459n 0.0 460n 0.9 485n 0.9 486n 0.0 639n 0.0 640n 0.9 665n 0.9 666n 0.0 739n 0.0 740n 0.9 765n 0.9 766n 0.0]

XDUT (vin clk mode rst out metric) idtmod_clock_phase_meter

tran tran stop=780n
save vin clk mode rst out metric
