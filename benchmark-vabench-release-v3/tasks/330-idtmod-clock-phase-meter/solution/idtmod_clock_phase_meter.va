`include "constants.vams"
`include "disciplines.vams"

module idtmod_clock_phase_meter (
    input  electrical vin,
    input  electrical clk,
    input  electrical mode,
    input  electrical rst,
    output electrical out,
    output electrical metric
);
parameter real vth = 0.45;
parameter real vhi = 0.9;
parameter real tr = 200p;
real out_v;
real metric_v;
integer count_q;
integer state_q;
real phase_q;
real freq_q;
real sample_q;
analog begin
    @(initial_step) begin
        out_v = 0.0;
        metric_v = 0.0;
        count_q = 0;
        state_q = 0;
        sample_q = 0.0;
    end
    freq_q = 1.25e6 + 0.5e6 * V(vin);
    phase_q = idtmod((V(rst) > vth) ? 0.0 : freq_q, 0.0, 1.0);
    @(cross(V(clk) - vth, +1)) begin
        if (V(rst) > vth) begin
            sample_q = 0.0;
            metric_v = 0.0;
        end else begin
            sample_q = phase_q;
            metric_v = (sample_q > V(mode)) ? vhi : 0.0;
            count_q = count_q + 1;
        end
    end
    out_v = sample_q * vhi;
    V(out) <+ transition(out_v, 0.0, tr, tr);
    V(metric) <+ transition(metric_v, 0.0, tr, tr);
end
endmodule
