`include "constants.vams"
`include "disciplines.vams"

module case_resettable_state_decoder (
    input  electrical vin,
    input  electrical clk,
    input  electrical mode,
    input  electrical rst,
    output electrical out,
    output electrical metric
);
parameter real vth = 0.45;
parameter real vhi = 0.9;
parameter real tr = 200p;
real out_v;
real metric_v;
integer count_q;
integer state_q;
analog begin
    @(initial_step) begin
        out_v = 0.0;
        metric_v = 0.0;
        count_q = 0;
        state_q = 0;
    end
    @(cross(V(clk) - vth, +1) or cross(V(rst) - vth, +1)) begin
        if (V(rst) > vth) begin
            state_q = 0;
            out_v = 0.0;
            metric_v = 0.0;
        end else begin
            state_q = (V(mode) < 0.225) ? 0 : ((V(mode) < 0.45) ? 1 : ((V(mode) < 0.675) ? 2 : 3));
            case (state_q)
                0: begin out_v = 0.20 * V(vin); metric_v = 0.00; end
                1: begin out_v = 0.50 * V(vin); metric_v = 0.30; end
                2: begin out_v = 0.75 * V(vin); metric_v = 0.60; end
                default: begin out_v = V(vin); metric_v = 0.90; end
            endcase
        end
    end
    V(out) <+ transition(out_v, 0.0, tr, tr);
    V(metric) <+ transition(metric_v, 0.0, tr, tr);
end
endmodule
