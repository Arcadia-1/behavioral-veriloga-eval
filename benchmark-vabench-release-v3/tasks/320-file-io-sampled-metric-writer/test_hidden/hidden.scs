simulator lang=spectre
global 0

ahdl_include "file_io_sampled_metric_writer.va"

Vvin (vin 0) vsource type=pwl wave=[ 0n 0.90 12n 0.90 12.1n 0.18 39n 0.18 40n 0.36 59n 0.36 60n 0.72 79n 0.72 80n 0.54 90n 0.54 ]
Vmode (mode 0) vsource type=pwl wave=[ 0n 0.0 90n 0.0 ]
Vrst (rst 0) vsource type=pwl wave=[ 0n 0.9 12n 0.9 12.1n 0 90n 0 ]
Vclk (clk 0) vsource type=pwl wave=[ 0n 0 4.9n 0 5.0n 0.9 5.5n 0.9 5.6n 0 24.9n 0 25.0n 0.9 25.5n 0.9 25.6n 0 44.9n 0 45.0n 0.9 45.5n 0.9 45.6n 0 64.9n 0 65.0n 0.9 65.5n 0.9 65.6n 0 84.9n 0 85.0n 0.9 85.5n 0.9 85.6n 0 90n 0 ]

XDUT (vin clk mode rst out metric) file_io_sampled_metric_writer

tran tran stop=90n
save vin clk mode rst out metric
