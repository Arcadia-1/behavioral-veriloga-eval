`include "constants.vams"
`include "disciplines.vams"

module file_io_sampled_metric_writer (
    input  electrical vin,
    input  electrical clk,
    input  electrical mode,
    input  electrical rst,
    output electrical out,
    output electrical metric
);
parameter real vth = 0.45;
parameter real vhi = 0.9;
parameter real tr = 200p;
real out_v;
real metric_v;
integer count_q;
integer state_q;
integer fd;
real sample_q;
analog begin
    @(initial_step) begin
        out_v = 0.0;
        metric_v = 0.0;
        count_q = 0;
        state_q = 0;
        sample_q = 0.0;
        fd = $fopen("samples.out", "w");
    end
    @(cross(V(clk) - vth, +1) or cross(V(rst) - vth, +1)) begin
        if (V(rst) > vth) begin
            count_q = 0;
            state_q = 0;
            sample_q = 0.0;
            out_v = 0.0;
            metric_v = 0.0;
        end else begin
            count_q = count_q + 1;
            state_q = count_q;
            sample_q = V(vin);
            out_v = sample_q;
            metric_v = sample_q / vhi;
            if (metric_v > 1.0) metric_v = 1.0;
            if (metric_v < 0.0) metric_v = 0.0;
            $fwrite(fd, "sample=%0d value=%.3f metric=%.3f\n", count_q, sample_q, metric_v);
        end
    end
    @(final_step) begin
        $fclose(fd);
    end
    V(out) <+ transition(out_v, 0.0, tr, tr);
    V(metric) <+ transition(metric_v, 0.0, tr, tr);
end
endmodule
