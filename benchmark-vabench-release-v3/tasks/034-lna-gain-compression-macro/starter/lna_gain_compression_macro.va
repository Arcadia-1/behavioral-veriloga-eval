`include "constants.vams"
`include "disciplines.vams"

module lna_gain_compression_macro(clk, rst, vin, out, metric);
input clk, rst, vin;
output out, metric;
electrical clk, rst, vin, out, metric;
parameter real tr = 100p;
parameter real vth = 0.45;
parameter real gain = 2.2;

    // TODO: implement the behavior described in instruction.md.
endmodule
