simulator lang=spectre
global 0

ahdl_include "source_dff_reset.va"

Vclk (vclk 0) vsource type=pulse val0=0 val1=0.9 delay=5n period=10n width=4n rise=100p fall=100p
Vd (vin_d 0) vsource type=pwl wave=[0 0.9 12n 0.9 12.2n 0 22n 0 22.2n 0.9 42n 0.9]
Vrst (rst 0) vsource type=pwl wave=[0 0 26n 0 27n 0.9 30n 0.9 31n 0 42n 0]

XDUT (vin_d vclk rst vout_q vout_qbar) source_dff_reset

tran tran stop=32n maxstep=50p
save vin_d vclk rst vout_q vout_qbar
