simulator lang=spectre
global 0

ahdl_include "above_window_qualifier.va"

Vvin (vin 0) vsource type=pwl wave=[0 0.1 89n 0.1 90n 0.76 160n 0.76 161n 0.1 239n 0.1 240n 0.80 330n 0.80 331n 0.1 639n 0.1 640n 0.78 760n 0.78]
Vmode (mode 0) vsource dc=0.0 type=dc
Vrst (rst 0) vsource type=pwl wave=[0 0.0 419n 0.0 420n 0.9 449n 0.9 450n 0.0 760n 0.0]
Vclk (clk 0) vsource dc=0.0 type=dc

XDUT (vin clk mode rst out metric) above_window_qualifier

tran tran stop=760n
save vin clk mode rst out metric
