`include "constants.vams"
`include "disciplines.vams"

module above_window_qualifier (
    input  electrical vin,
    input  electrical clk,
    input  electrical mode,
    input  electrical rst,
    output electrical out,
    output electrical metric
);
parameter real vth = 0.45;
parameter real vhi = 0.9;
parameter real tr = 200p;
real out_v;
real metric_v;
integer count_q;
integer state_q;
real last_t;
real prev_t;
real period_q;
real lc_q;
analog begin
    @(initial_step) begin
        out_v = 0.0;
        metric_v = 0.0;
        count_q = 0;
        state_q = 0;
        last_t = -1.0;
        prev_t = -1.0;
        period_q = 0.0;
        lc_q = -1.0;
    end
    lc_q = last_crossing(V(vin) - vth, +1, 0.0, 1e-12);
    @(above(V(vin) - vth)) begin
        state_q = 1;
        out_v = vhi;
    end
    @(cross(V(vin) - vth, +1, 0.0, 1e-12)) begin
        prev_t = last_t;
        last_t = lc_q;
        if (prev_t > 0.0) period_q = last_t - prev_t;
        metric_v = ((prev_t > 0.0) && (period_q >= 120e-9) && (period_q <= 260e-9)) ? vhi : 0.0;
    end
    @(cross(V(rst) - vth, +1)) begin
        state_q = 0;
        out_v = 0.0;
        metric_v = 0.0;
        last_t = -1.0;
        prev_t = -1.0;
        period_q = 0.0;
        lc_q = -1.0;
    end
    out_v = (state_q != 0) ? vhi : 0.0;
    V(out) <+ transition(out_v, 0.0, tr, tr);
    V(metric) <+ transition(metric_v, 0.0, tr, tr);
end
endmodule
