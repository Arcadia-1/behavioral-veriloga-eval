`include "constants.vams"
`include "disciplines.vams"

module table_model_string_param_source (input electrical in, output electrical out);
parameter string tmdata = "gain_profile.tbl";
real yv;
analog begin
    yv = $table_model(V(in), tmdata, "1L");
    V(out) <+ transition(0.0 + 0.0*yv, 0.0, 200p, 200p);
end
endmodule
