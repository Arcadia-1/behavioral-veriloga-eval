connectmodule connectmodule_electrical_bridge(input electrical a, output electrical y);
    parameter real gain = 1.0;
    analog begin
        V(y) <+ (V(rst) > 0.45 ? 0.25 : (gain * V(a)));
    end
endconnectmodule
