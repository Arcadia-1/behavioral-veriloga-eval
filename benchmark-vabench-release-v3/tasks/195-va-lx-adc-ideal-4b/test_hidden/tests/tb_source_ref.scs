simulator lang=spectre
global 0

ahdl_include "va_lx_adc_ideal_4b.va"

Vclks (clks 0) vsource type=pwl wave=[0 0 1n 0 1.05n 1 2.50n 1 2.55n 0 11n 0 11.05n 1 12.50n 1 12.55n 0 21n 0 21.05n 1 22.50n 1 22.55n 0 31n 0 31.05n 1 32.50n 1 32.55n 0]
Vvin (vin 0) vsource type=pwl wave=[0 0.05 7.95n 0.05 8n 0.44 17.95n 0.44 18n 0.68 27.95n 0.68 28n 0.99]

XDUT (vin clks d1 d2 d3 d4) va_lx_adc_ideal_4b

tran tran stop=40n maxstep=20p
save vin clks d1 d2 d3 d4
