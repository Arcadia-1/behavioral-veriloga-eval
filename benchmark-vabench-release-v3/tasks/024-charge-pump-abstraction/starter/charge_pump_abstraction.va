`include "constants.vams"
`include "disciplines.vams"

module charge_pump_abstraction(clk, rst, up, dn, vctrl, metric);
input clk, rst, up, dn;
output vctrl, metric;
electrical clk, rst, up, dn, vctrl, metric;
parameter real tr = 100p;
parameter real vth = 0.45;
parameter real step = 0.06;
parameter real vmin = 0.05;
parameter real vmax = 0.85;

    // TODO: implement the behavior described in visible/prompt.md.
    // This starter is intentionally incomplete; implement the public behavior contract.
endmodule
