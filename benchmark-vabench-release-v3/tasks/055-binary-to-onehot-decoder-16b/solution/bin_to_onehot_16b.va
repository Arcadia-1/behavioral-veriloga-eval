`include "constants.vams"
`include "disciplines.vams"

module bin_to_onehot_16b(
    input electrical en,
    input electrical [3:0] b,
    output electrical [15:0] oh
);
    parameter real vdd = 0.9;
    parameter real vth = 0.45;
    parameter real tr = 20p;

    integer code;
    integer j;
    genvar i;

    analog begin
        code = 0;
        for (j = 0; j < 4; j = j + 1) if (V(b[j]) > vth) code = code + (1 << j);
        for (i = 0; i < 16; i = i + 1) begin
            V(oh[i]) <+ transition(((V(en) > vth) && (i == code)) ? vdd : 0.0, 0, tr, tr);
        end
    end
endmodule
