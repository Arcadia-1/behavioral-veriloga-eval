simulator lang=spectre
global 0

ahdl_include "bin_to_onehot_16b.va"

Ven (en 0) vsource type=pwl wave=[ 0n 0.9 9n 0.9 10n 0.9 19n 0.9 20n 0.9 29n 0.9 30n 0.9 39n 0.9 40n 0.9 49n 0.9 50n 0.9 59n 0.9 60n 0.9 69n 0.9 70n 0.9 79n 0.9 80n 0.9 89n 0.9 90n 0.9 99n 0.9 100n 0.9 109n 0.9 110n 0.9 119n 0.9 120n 0.9 129n 0.9 130n 0.9 139n 0.9 140n 0.9 149n 0.9 150n 0.9 159n 0.9 160n 0 169n 0 ]
Vb3 (b3 0) vsource type=pwl wave=[ 0n 0 9n 0 10n 0 19n 0 20n 0 29n 0 30n 0 39n 0 40n 0 49n 0 50n 0 59n 0 60n 0 69n 0 70n 0 79n 0 80n 0.9 89n 0.9 90n 0.9 99n 0.9 100n 0.9 109n 0.9 110n 0.9 119n 0.9 120n 0.9 129n 0.9 130n 0.9 139n 0.9 140n 0.9 149n 0.9 150n 0.9 159n 0.9 160n 0 169n 0 ]
Vb2 (b2 0) vsource type=pwl wave=[ 0n 0 9n 0 10n 0 19n 0 20n 0 29n 0 30n 0 39n 0 40n 0.9 49n 0.9 50n 0.9 59n 0.9 60n 0.9 69n 0.9 70n 0.9 79n 0.9 80n 0 89n 0 90n 0 99n 0 100n 0 109n 0 110n 0 119n 0 120n 0.9 129n 0.9 130n 0.9 139n 0.9 140n 0.9 149n 0.9 150n 0.9 159n 0.9 160n 0.9 169n 0.9 ]
Vb1 (b1 0) vsource type=pwl wave=[ 0n 0 9n 0 10n 0 19n 0 20n 0.9 29n 0.9 30n 0.9 39n 0.9 40n 0 49n 0 50n 0 59n 0 60n 0.9 69n 0.9 70n 0.9 79n 0.9 80n 0 89n 0 90n 0 99n 0 100n 0.9 109n 0.9 110n 0.9 119n 0.9 120n 0 129n 0 130n 0 139n 0 140n 0.9 149n 0.9 150n 0.9 159n 0.9 160n 0.9 169n 0.9 ]
Vb0 (b0 0) vsource type=pwl wave=[ 0n 0 9n 0 10n 0.9 19n 0.9 20n 0 29n 0 30n 0.9 39n 0.9 40n 0 49n 0 50n 0.9 59n 0.9 60n 0 69n 0 70n 0.9 79n 0.9 80n 0 89n 0 90n 0.9 99n 0.9 100n 0 109n 0 110n 0.9 119n 0.9 120n 0 129n 0 130n 0.9 139n 0.9 140n 0 149n 0 150n 0.9 159n 0.9 160n 0.9 169n 0.9 ]

XDUT (en b3 b2 b1 b0 oh15 oh14 oh13 oh12 oh11 oh10 oh9 oh8 oh7 oh6 oh5 oh4 oh3 oh2 oh1 oh0) bin_to_onehot_16b

tran tran stop=170n maxstep=200p
save en b3 b2 b1 b0 oh15 oh14 oh13 oh12 oh11 oh10 oh9 oh8 oh7 oh6 oh5 oh4 oh3 oh2 oh1 oh0
