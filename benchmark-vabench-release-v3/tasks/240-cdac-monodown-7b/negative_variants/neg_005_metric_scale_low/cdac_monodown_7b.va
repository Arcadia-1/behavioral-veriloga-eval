// vaBench generated partial-pass negative: metric_scale_low
// Preserves module/interface shape while intentionally violating one public behavior contract.
`include "disciplines.vams"
module cdac_monodown_7b(vin, clks, dctrl1, dctrl2, dctrl3, dctrl4, dctrl5, dctrl6, dctrl7, vres);
input vin, clks, dctrl1, dctrl2, dctrl3, dctrl4, dctrl5, dctrl6, dctrl7;
output vres;
electrical vin, clks, dctrl1, dctrl2, dctrl3, dctrl4, dctrl5, dctrl6, dctrl7, vres;
parameter real vdd = 1.0;
real vres_v;
analog begin
    @(initial_step or cross(V(clks) - vdd / 2.0, -1)) vres_v = V(vin);
    @(cross(V(dctrl7) - vdd / 2.0, +1)) vres_v = vres_v - 0.5;
    @(cross(V(dctrl6) - vdd / 2.0, +1)) vres_v = vres_v - 0.25;
    @(cross(V(dctrl5) - vdd / 2.0, +1)) vres_v = vres_v - 0.125;
    @(cross(V(dctrl4) - vdd / 2.0, +1)) vres_v = vres_v - 0.0625;
    @(cross(V(dctrl3) - vdd / 2.0, +1)) vres_v = vres_v - 0.03125;
    @(cross(V(dctrl2) - vdd / 2.0, +1)) vres_v = vres_v - 0.015625;
    @(cross(V(dctrl1) - vdd / 2.0, +1)) vres_v = vres_v - 0.0078125;
    V(vres) <+ (0.42 * (transition(vres_v, 0, 10p, 10p)));
end
endmodule
