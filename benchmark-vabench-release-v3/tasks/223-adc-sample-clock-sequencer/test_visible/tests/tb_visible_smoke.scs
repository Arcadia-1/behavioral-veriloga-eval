simulator lang=spectre
global 0
ahdl_include "adc_sample_clock_sequencer.va"
XDUT (rst s ss nc_az nc conv) adc_sample_clock_sequencer
tran tran stop=14n maxstep=20p
save rst s ss nc_az nc conv
