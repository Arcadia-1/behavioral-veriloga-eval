simulator lang=spectre
global 0

ahdl_include "multiphase_clock_generator_4ph.va"

XDUT (clk0 clk90 clk180 clk270) multiphase_clock_generator_4ph

tran tran stop=8n maxstep=100p
save clk0 clk90 clk180 clk270
