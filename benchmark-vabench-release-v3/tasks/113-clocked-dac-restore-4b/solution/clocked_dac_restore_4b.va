`include "constants.vams"
`include "disciplines.vams"

module clocked_dac_restore_4b(D3, D2, D1, D0, CLK, VOUT);
    input D3, D2, D1, D0, CLK;
    output VOUT;
    electrical D3, D2, D1, D0, CLK, VOUT;

    parameter real vth = 0.45;
    parameter real lsb = 1.8 / 16.0;
    parameter real tr = 20p;
    real vout;
    integer code;

    analog begin
        @(initial_step) begin
            vout = -0.84375;
        end

        @(cross(V(CLK) - vth, +1)) begin
            code = 0;
            code = code + ((V(D3) > vth) ? 8 : 0);
            code = code + ((V(D2) > vth) ? 4 : 0);
            code = code + ((V(D1) > vth) ? 2 : 0);
            code = code + ((V(D0) > vth) ? 1 : 0);
            vout = (code + 0.5) * lsb - 0.9;
        end

        V(VOUT) <+ transition(vout, 0, tr, tr);
    end
endmodule
