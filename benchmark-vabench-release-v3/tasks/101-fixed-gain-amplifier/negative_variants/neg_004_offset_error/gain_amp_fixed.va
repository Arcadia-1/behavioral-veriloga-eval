`include "constants.vams"
`include "disciplines.vams"
`default_transition 30p

module gain_amp_fixed(VIN_P, VIN_N, VOUT_P, VOUT_N);
    input electrical VIN_P, VIN_N;
    output electrical VOUT_P, VOUT_N;
    parameter real vdd = 0.9;
    parameter real ACTUAL_GAIN = 8.64;

    real vout_diff;
    analog begin
        vout_diff = ACTUAL_GAIN * V(VIN_P, VIN_N);
        V(VOUT_P) <+ vdd/2 + vout_diff * 0.5 + 0.05;  // 50mV offset
        V(VOUT_N) <+ vdd/2 - vout_diff * 0.5 + 0.05;
    end
endmodule
