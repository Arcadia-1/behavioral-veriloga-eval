`include "constants.vams"
`include "disciplines.vams"

module config_latch_128b(
    en,
    d127,
    d126,
    d125,
    d124,
    d123,
    d122,
    d121,
    d120,
    d119,
    d118,
    d117,
    d116,
    d115,
    d114,
    d113,
    d112,
    d111,
    d110,
    d109,
    d108,
    d107,
    d106,
    d105,
    d104,
    d103,
    d102,
    d101,
    d100,
    d99,
    d98,
    d97,
    d96,
    d95,
    d94,
    d93,
    d92,
    d91,
    d90,
    d89,
    d88,
    d87,
    d86,
    d85,
    d84,
    d83,
    d82,
    d81,
    d80,
    d79,
    d78,
    d77,
    d76,
    d75,
    d74,
    d73,
    d72,
    d71,
    d70,
    d69,
    d68,
    d67,
    d66,
    d65,
    d64,
    d63,
    d62,
    d61,
    d60,
    d59,
    d58,
    d57,
    d56,
    d55,
    d54,
    d53,
    d52,
    d51,
    d50,
    d49,
    d48,
    d47,
    d46,
    d45,
    d44,
    d43,
    d42,
    d41,
    d40,
    d39,
    d38,
    d37,
    d36,
    d35,
    d34,
    d33,
    d32,
    d31,
    d30,
    d29,
    d28,
    d27,
    d26,
    d25,
    d24,
    d23,
    d22,
    d21,
    d20,
    d19,
    d18,
    d17,
    d16,
    d15,
    d14,
    d13,
    d12,
    d11,
    d10,
    d9,
    d8,
    d7,
    d6,
    d5,
    d4,
    d3,
    d2,
    d1,
    d0,
    q127,
    q126,
    q125,
    q124,
    q123,
    q122,
    q121,
    q120,
    q119,
    q118,
    q117,
    q116,
    q115,
    q114,
    q113,
    q112,
    q111,
    q110,
    q109,
    q108,
    q107,
    q106,
    q105,
    q104,
    q103,
    q102,
    q101,
    q100,
    q99,
    q98,
    q97,
    q96,
    q95,
    q94,
    q93,
    q92,
    q91,
    q90,
    q89,
    q88,
    q87,
    q86,
    q85,
    q84,
    q83,
    q82,
    q81,
    q80,
    q79,
    q78,
    q77,
    q76,
    q75,
    q74,
    q73,
    q72,
    q71,
    q70,
    q69,
    q68,
    q67,
    q66,
    q65,
    q64,
    q63,
    q62,
    q61,
    q60,
    q59,
    q58,
    q57,
    q56,
    q55,
    q54,
    q53,
    q52,
    q51,
    q50,
    q49,
    q48,
    q47,
    q46,
    q45,
    q44,
    q43,
    q42,
    q41,
    q40,
    q39,
    q38,
    q37,
    q36,
    q35,
    q34,
    q33,
    q32,
    q31,
    q30,
    q29,
    q28,
    q27,
    q26,
    q25,
    q24,
    q23,
    q22,
    q21,
    q20,
    q19,
    q18,
    q17,
    q16,
    q15,
    q14,
    q13,
    q12,
    q11,
    q10,
    q9,
    q8,
    q7,
    q6,
    q5,
    q4,
    q3,
    q2,
    q1,
    q0
);
    input en, d127, d126, d125, d124, d123, d122, d121, d120, d119, d118, d117, d116, d115, d114, d113, d112, d111, d110, d109, d108, d107, d106, d105, d104, d103, d102, d101, d100, d99, d98, d97, d96, d95, d94, d93, d92, d91, d90, d89, d88, d87, d86, d85, d84, d83, d82, d81, d80, d79, d78, d77, d76, d75, d74, d73, d72, d71, d70, d69, d68, d67, d66, d65, d64, d63, d62, d61, d60, d59, d58, d57, d56, d55, d54, d53, d52, d51, d50, d49, d48, d47, d46, d45, d44, d43, d42, d41, d40, d39, d38, d37, d36, d35, d34, d33, d32, d31, d30, d29, d28, d27, d26, d25, d24, d23, d22, d21, d20, d19, d18, d17, d16, d15, d14, d13, d12, d11, d10, d9, d8, d7, d6, d5, d4, d3, d2, d1, d0;
    output q127, q126, q125, q124, q123, q122, q121, q120, q119, q118, q117, q116, q115, q114, q113, q112, q111, q110, q109, q108, q107, q106, q105, q104, q103, q102, q101, q100, q99, q98, q97, q96, q95, q94, q93, q92, q91, q90, q89, q88, q87, q86, q85, q84, q83, q82, q81, q80, q79, q78, q77, q76, q75, q74, q73, q72, q71, q70, q69, q68, q67, q66, q65, q64, q63, q62, q61, q60, q59, q58, q57, q56, q55, q54, q53, q52, q51, q50, q49, q48, q47, q46, q45, q44, q43, q42, q41, q40, q39, q38, q37, q36, q35, q34, q33, q32, q31, q30, q29, q28, q27, q26, q25, q24, q23, q22, q21, q20, q19, q18, q17, q16, q15, q14, q13, q12, q11, q10, q9, q8, q7, q6, q5, q4, q3, q2, q1, q0;
    electrical en, d127, d126, d125, d124, d123, d122, d121, d120, d119, d118, d117, d116, d115, d114, d113, d112, d111, d110, d109, d108, d107, d106, d105, d104, d103, d102, d101, d100, d99, d98, d97, d96, d95, d94, d93, d92, d91, d90, d89, d88, d87, d86, d85, d84, d83, d82, d81, d80, d79, d78, d77, d76, d75, d74, d73, d72, d71, d70, d69, d68, d67, d66, d65, d64, d63, d62, d61, d60, d59, d58, d57, d56, d55, d54, d53, d52, d51, d50, d49, d48, d47, d46, d45, d44, d43, d42, d41, d40, d39, d38, d37, d36, d35, d34, d33, d32, d31, d30, d29, d28, d27, d26, d25, d24, d23, d22, d21, d20, d19, d18, d17, d16, d15, d14, d13, d12, d11, d10, d9, d8, d7, d6, d5, d4, d3, d2, d1, d0, q127, q126, q125, q124, q123, q122, q121, q120, q119, q118, q117, q116, q115, q114, q113, q112, q111, q110, q109, q108, q107, q106, q105, q104, q103, q102, q101, q100, q99, q98, q97, q96, q95, q94, q93, q92, q91, q90, q89, q88, q87, q86, q85, q84, q83, q82, q81, q80, q79, q78, q77, q76, q75, q74, q73, q72, q71, q70, q69, q68, q67, q66, q65, q64, q63, q62, q61, q60, q59, q58, q57, q56, q55, q54, q53, q52, q51, q50, q49, q48, q47, q46, q45, q44, q43, q42, q41, q40, q39, q38, q37, q36, q35, q34, q33, q32, q31, q30, q29, q28, q27, q26, q25, q24, q23, q22, q21, q20, q19, q18, q17, q16, q15, q14, q13, q12, q11, q10, q9, q8, q7, q6, q5, q4, q3, q2, q1, q0;
    parameter real vdd = 0.9;
    parameter real vth = 0.45;
    parameter real tr = 20p;
    analog begin
        V(q127) <+ transition(0.0, 0, tr, tr);
        V(q126) <+ transition(0.0, 0, tr, tr);
        V(q125) <+ transition(0.0, 0, tr, tr);
        V(q124) <+ transition(0.0, 0, tr, tr);
        V(q123) <+ transition(0.0, 0, tr, tr);
        V(q122) <+ transition(0.0, 0, tr, tr);
        V(q121) <+ transition(0.0, 0, tr, tr);
        V(q120) <+ transition(0.0, 0, tr, tr);
        V(q119) <+ transition(0.0, 0, tr, tr);
        V(q118) <+ transition(0.0, 0, tr, tr);
        V(q117) <+ transition(0.0, 0, tr, tr);
        V(q116) <+ transition(0.0, 0, tr, tr);
        V(q115) <+ transition(0.0, 0, tr, tr);
        V(q114) <+ transition(0.0, 0, tr, tr);
        V(q113) <+ transition(0.0, 0, tr, tr);
        V(q112) <+ transition(0.0, 0, tr, tr);
        V(q111) <+ transition(0.0, 0, tr, tr);
        V(q110) <+ transition(0.0, 0, tr, tr);
        V(q109) <+ transition(0.0, 0, tr, tr);
        V(q108) <+ transition(0.0, 0, tr, tr);
        V(q107) <+ transition(0.0, 0, tr, tr);
        V(q106) <+ transition(0.0, 0, tr, tr);
        V(q105) <+ transition(0.0, 0, tr, tr);
        V(q104) <+ transition(0.0, 0, tr, tr);
        V(q103) <+ transition(0.0, 0, tr, tr);
        V(q102) <+ transition(0.0, 0, tr, tr);
        V(q101) <+ transition(0.0, 0, tr, tr);
        V(q100) <+ transition(0.0, 0, tr, tr);
        V(q99) <+ transition(0.0, 0, tr, tr);
        V(q98) <+ transition(0.0, 0, tr, tr);
        V(q97) <+ transition(0.0, 0, tr, tr);
        V(q96) <+ transition(0.0, 0, tr, tr);
        V(q95) <+ transition(0.0, 0, tr, tr);
        V(q94) <+ transition(0.0, 0, tr, tr);
        V(q93) <+ transition(0.0, 0, tr, tr);
        V(q92) <+ transition(0.0, 0, tr, tr);
        V(q91) <+ transition(0.0, 0, tr, tr);
        V(q90) <+ transition(0.0, 0, tr, tr);
        V(q89) <+ transition(0.0, 0, tr, tr);
        V(q88) <+ transition(0.0, 0, tr, tr);
        V(q87) <+ transition(0.0, 0, tr, tr);
        V(q86) <+ transition(0.0, 0, tr, tr);
        V(q85) <+ transition(0.0, 0, tr, tr);
        V(q84) <+ transition(0.0, 0, tr, tr);
        V(q83) <+ transition(0.0, 0, tr, tr);
        V(q82) <+ transition(0.0, 0, tr, tr);
        V(q81) <+ transition(0.0, 0, tr, tr);
        V(q80) <+ transition(0.0, 0, tr, tr);
        V(q79) <+ transition(0.0, 0, tr, tr);
        V(q78) <+ transition(0.0, 0, tr, tr);
        V(q77) <+ transition(0.0, 0, tr, tr);
        V(q76) <+ transition(0.0, 0, tr, tr);
        V(q75) <+ transition(0.0, 0, tr, tr);
        V(q74) <+ transition(0.0, 0, tr, tr);
        V(q73) <+ transition(0.0, 0, tr, tr);
        V(q72) <+ transition(0.0, 0, tr, tr);
        V(q71) <+ transition(0.0, 0, tr, tr);
        V(q70) <+ transition(0.0, 0, tr, tr);
        V(q69) <+ transition(0.0, 0, tr, tr);
        V(q68) <+ transition(0.0, 0, tr, tr);
        V(q67) <+ transition(0.0, 0, tr, tr);
        V(q66) <+ transition(0.0, 0, tr, tr);
        V(q65) <+ transition(0.0, 0, tr, tr);
        V(q64) <+ transition(0.0, 0, tr, tr);
        V(q63) <+ transition(0.0, 0, tr, tr);
        V(q62) <+ transition(0.0, 0, tr, tr);
        V(q61) <+ transition(0.0, 0, tr, tr);
        V(q60) <+ transition(0.0, 0, tr, tr);
        V(q59) <+ transition(0.0, 0, tr, tr);
        V(q58) <+ transition(0.0, 0, tr, tr);
        V(q57) <+ transition(0.0, 0, tr, tr);
        V(q56) <+ transition(0.0, 0, tr, tr);
        V(q55) <+ transition(0.0, 0, tr, tr);
        V(q54) <+ transition(0.0, 0, tr, tr);
        V(q53) <+ transition(0.0, 0, tr, tr);
        V(q52) <+ transition(0.0, 0, tr, tr);
        V(q51) <+ transition(0.0, 0, tr, tr);
        V(q50) <+ transition(0.0, 0, tr, tr);
        V(q49) <+ transition(0.0, 0, tr, tr);
        V(q48) <+ transition(0.0, 0, tr, tr);
        V(q47) <+ transition(0.0, 0, tr, tr);
        V(q46) <+ transition(0.0, 0, tr, tr);
        V(q45) <+ transition(0.0, 0, tr, tr);
        V(q44) <+ transition(0.0, 0, tr, tr);
        V(q43) <+ transition(0.0, 0, tr, tr);
        V(q42) <+ transition(0.0, 0, tr, tr);
        V(q41) <+ transition(0.0, 0, tr, tr);
        V(q40) <+ transition(0.0, 0, tr, tr);
        V(q39) <+ transition(0.0, 0, tr, tr);
        V(q38) <+ transition(0.0, 0, tr, tr);
        V(q37) <+ transition(0.0, 0, tr, tr);
        V(q36) <+ transition(0.0, 0, tr, tr);
        V(q35) <+ transition(0.0, 0, tr, tr);
        V(q34) <+ transition(0.0, 0, tr, tr);
        V(q33) <+ transition(0.0, 0, tr, tr);
        V(q32) <+ transition(0.0, 0, tr, tr);
        V(q31) <+ transition(0.0, 0, tr, tr);
        V(q30) <+ transition(0.0, 0, tr, tr);
        V(q29) <+ transition(0.0, 0, tr, tr);
        V(q28) <+ transition(0.0, 0, tr, tr);
        V(q27) <+ transition(0.0, 0, tr, tr);
        V(q26) <+ transition(0.0, 0, tr, tr);
        V(q25) <+ transition(0.0, 0, tr, tr);
        V(q24) <+ transition(0.0, 0, tr, tr);
        V(q23) <+ transition(0.0, 0, tr, tr);
        V(q22) <+ transition(0.0, 0, tr, tr);
        V(q21) <+ transition(0.0, 0, tr, tr);
        V(q20) <+ transition(0.0, 0, tr, tr);
        V(q19) <+ transition(0.0, 0, tr, tr);
        V(q18) <+ transition(0.0, 0, tr, tr);
        V(q17) <+ transition(0.0, 0, tr, tr);
        V(q16) <+ transition(0.0, 0, tr, tr);
        V(q15) <+ transition(0.0, 0, tr, tr);
        V(q14) <+ transition(0.0, 0, tr, tr);
        V(q13) <+ transition(0.0, 0, tr, tr);
        V(q12) <+ transition(0.0, 0, tr, tr);
        V(q11) <+ transition(0.0, 0, tr, tr);
        V(q10) <+ transition(0.0, 0, tr, tr);
        V(q9) <+ transition(0.0, 0, tr, tr);
        V(q8) <+ transition(0.0, 0, tr, tr);
        V(q7) <+ transition(0.0, 0, tr, tr);
        V(q6) <+ transition(0.0, 0, tr, tr);
        V(q5) <+ transition(0.0, 0, tr, tr);
        V(q4) <+ transition(0.0, 0, tr, tr);
        V(q3) <+ transition(0.0, 0, tr, tr);
        V(q2) <+ transition(0.0, 0, tr, tr);
        V(q1) <+ transition(0.0, 0, tr, tr);
        V(q0) <+ transition(0.0, 0, tr, tr);
    end
endmodule
