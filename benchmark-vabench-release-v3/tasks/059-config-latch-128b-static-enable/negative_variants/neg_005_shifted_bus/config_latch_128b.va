`include "constants.vams"
`include "disciplines.vams"

module config_latch_128b(
    en,
    d127,
    d126,
    d125,
    d124,
    d123,
    d122,
    d121,
    d120,
    d119,
    d118,
    d117,
    d116,
    d115,
    d114,
    d113,
    d112,
    d111,
    d110,
    d109,
    d108,
    d107,
    d106,
    d105,
    d104,
    d103,
    d102,
    d101,
    d100,
    d99,
    d98,
    d97,
    d96,
    d95,
    d94,
    d93,
    d92,
    d91,
    d90,
    d89,
    d88,
    d87,
    d86,
    d85,
    d84,
    d83,
    d82,
    d81,
    d80,
    d79,
    d78,
    d77,
    d76,
    d75,
    d74,
    d73,
    d72,
    d71,
    d70,
    d69,
    d68,
    d67,
    d66,
    d65,
    d64,
    d63,
    d62,
    d61,
    d60,
    d59,
    d58,
    d57,
    d56,
    d55,
    d54,
    d53,
    d52,
    d51,
    d50,
    d49,
    d48,
    d47,
    d46,
    d45,
    d44,
    d43,
    d42,
    d41,
    d40,
    d39,
    d38,
    d37,
    d36,
    d35,
    d34,
    d33,
    d32,
    d31,
    d30,
    d29,
    d28,
    d27,
    d26,
    d25,
    d24,
    d23,
    d22,
    d21,
    d20,
    d19,
    d18,
    d17,
    d16,
    d15,
    d14,
    d13,
    d12,
    d11,
    d10,
    d9,
    d8,
    d7,
    d6,
    d5,
    d4,
    d3,
    d2,
    d1,
    d0,
    q127,
    q126,
    q125,
    q124,
    q123,
    q122,
    q121,
    q120,
    q119,
    q118,
    q117,
    q116,
    q115,
    q114,
    q113,
    q112,
    q111,
    q110,
    q109,
    q108,
    q107,
    q106,
    q105,
    q104,
    q103,
    q102,
    q101,
    q100,
    q99,
    q98,
    q97,
    q96,
    q95,
    q94,
    q93,
    q92,
    q91,
    q90,
    q89,
    q88,
    q87,
    q86,
    q85,
    q84,
    q83,
    q82,
    q81,
    q80,
    q79,
    q78,
    q77,
    q76,
    q75,
    q74,
    q73,
    q72,
    q71,
    q70,
    q69,
    q68,
    q67,
    q66,
    q65,
    q64,
    q63,
    q62,
    q61,
    q60,
    q59,
    q58,
    q57,
    q56,
    q55,
    q54,
    q53,
    q52,
    q51,
    q50,
    q49,
    q48,
    q47,
    q46,
    q45,
    q44,
    q43,
    q42,
    q41,
    q40,
    q39,
    q38,
    q37,
    q36,
    q35,
    q34,
    q33,
    q32,
    q31,
    q30,
    q29,
    q28,
    q27,
    q26,
    q25,
    q24,
    q23,
    q22,
    q21,
    q20,
    q19,
    q18,
    q17,
    q16,
    q15,
    q14,
    q13,
    q12,
    q11,
    q10,
    q9,
    q8,
    q7,
    q6,
    q5,
    q4,
    q3,
    q2,
    q1,
    q0
);
    input en, d127, d126, d125, d124, d123, d122, d121, d120, d119, d118, d117, d116, d115, d114, d113, d112, d111, d110, d109, d108, d107, d106, d105, d104, d103, d102, d101, d100, d99, d98, d97, d96, d95, d94, d93, d92, d91, d90, d89, d88, d87, d86, d85, d84, d83, d82, d81, d80, d79, d78, d77, d76, d75, d74, d73, d72, d71, d70, d69, d68, d67, d66, d65, d64, d63, d62, d61, d60, d59, d58, d57, d56, d55, d54, d53, d52, d51, d50, d49, d48, d47, d46, d45, d44, d43, d42, d41, d40, d39, d38, d37, d36, d35, d34, d33, d32, d31, d30, d29, d28, d27, d26, d25, d24, d23, d22, d21, d20, d19, d18, d17, d16, d15, d14, d13, d12, d11, d10, d9, d8, d7, d6, d5, d4, d3, d2, d1, d0;
    output q127, q126, q125, q124, q123, q122, q121, q120, q119, q118, q117, q116, q115, q114, q113, q112, q111, q110, q109, q108, q107, q106, q105, q104, q103, q102, q101, q100, q99, q98, q97, q96, q95, q94, q93, q92, q91, q90, q89, q88, q87, q86, q85, q84, q83, q82, q81, q80, q79, q78, q77, q76, q75, q74, q73, q72, q71, q70, q69, q68, q67, q66, q65, q64, q63, q62, q61, q60, q59, q58, q57, q56, q55, q54, q53, q52, q51, q50, q49, q48, q47, q46, q45, q44, q43, q42, q41, q40, q39, q38, q37, q36, q35, q34, q33, q32, q31, q30, q29, q28, q27, q26, q25, q24, q23, q22, q21, q20, q19, q18, q17, q16, q15, q14, q13, q12, q11, q10, q9, q8, q7, q6, q5, q4, q3, q2, q1, q0;
    electrical en, d127, d126, d125, d124, d123, d122, d121, d120, d119, d118, d117, d116, d115, d114, d113, d112, d111, d110, d109, d108, d107, d106, d105, d104, d103, d102, d101, d100, d99, d98, d97, d96, d95, d94, d93, d92, d91, d90, d89, d88, d87, d86, d85, d84, d83, d82, d81, d80, d79, d78, d77, d76, d75, d74, d73, d72, d71, d70, d69, d68, d67, d66, d65, d64, d63, d62, d61, d60, d59, d58, d57, d56, d55, d54, d53, d52, d51, d50, d49, d48, d47, d46, d45, d44, d43, d42, d41, d40, d39, d38, d37, d36, d35, d34, d33, d32, d31, d30, d29, d28, d27, d26, d25, d24, d23, d22, d21, d20, d19, d18, d17, d16, d15, d14, d13, d12, d11, d10, d9, d8, d7, d6, d5, d4, d3, d2, d1, d0, q127, q126, q125, q124, q123, q122, q121, q120, q119, q118, q117, q116, q115, q114, q113, q112, q111, q110, q109, q108, q107, q106, q105, q104, q103, q102, q101, q100, q99, q98, q97, q96, q95, q94, q93, q92, q91, q90, q89, q88, q87, q86, q85, q84, q83, q82, q81, q80, q79, q78, q77, q76, q75, q74, q73, q72, q71, q70, q69, q68, q67, q66, q65, q64, q63, q62, q61, q60, q59, q58, q57, q56, q55, q54, q53, q52, q51, q50, q49, q48, q47, q46, q45, q44, q43, q42, q41, q40, q39, q38, q37, q36, q35, q34, q33, q32, q31, q30, q29, q28, q27, q26, q25, q24, q23, q22, q21, q20, q19, q18, q17, q16, q15, q14, q13, q12, q11, q10, q9, q8, q7, q6, q5, q4, q3, q2, q1, q0;
    parameter real vdd = 0.9;
    parameter real vth = 0.45;
    parameter real tr = 20p;
    analog begin
        V(q0) <+ transition((V(en) > vth && V(d1) > vth) ? vdd : 0.0, 0, tr, tr);
        V(q1) <+ transition((V(en) > vth && V(d2) > vth) ? vdd : 0.0, 0, tr, tr);
        V(q2) <+ transition((V(en) > vth && V(d3) > vth) ? vdd : 0.0, 0, tr, tr);
        V(q3) <+ transition((V(en) > vth && V(d4) > vth) ? vdd : 0.0, 0, tr, tr);
        V(q4) <+ transition((V(en) > vth && V(d5) > vth) ? vdd : 0.0, 0, tr, tr);
        V(q5) <+ transition((V(en) > vth && V(d6) > vth) ? vdd : 0.0, 0, tr, tr);
        V(q6) <+ transition((V(en) > vth && V(d7) > vth) ? vdd : 0.0, 0, tr, tr);
        V(q7) <+ transition((V(en) > vth && V(d8) > vth) ? vdd : 0.0, 0, tr, tr);
        V(q8) <+ transition((V(en) > vth && V(d9) > vth) ? vdd : 0.0, 0, tr, tr);
        V(q9) <+ transition((V(en) > vth && V(d10) > vth) ? vdd : 0.0, 0, tr, tr);
        V(q10) <+ transition((V(en) > vth && V(d11) > vth) ? vdd : 0.0, 0, tr, tr);
        V(q11) <+ transition((V(en) > vth && V(d12) > vth) ? vdd : 0.0, 0, tr, tr);
        V(q12) <+ transition((V(en) > vth && V(d13) > vth) ? vdd : 0.0, 0, tr, tr);
        V(q13) <+ transition((V(en) > vth && V(d14) > vth) ? vdd : 0.0, 0, tr, tr);
        V(q14) <+ transition((V(en) > vth && V(d15) > vth) ? vdd : 0.0, 0, tr, tr);
        V(q15) <+ transition((V(en) > vth && V(d16) > vth) ? vdd : 0.0, 0, tr, tr);
        V(q16) <+ transition((V(en) > vth && V(d17) > vth) ? vdd : 0.0, 0, tr, tr);
        V(q17) <+ transition((V(en) > vth && V(d18) > vth) ? vdd : 0.0, 0, tr, tr);
        V(q18) <+ transition((V(en) > vth && V(d19) > vth) ? vdd : 0.0, 0, tr, tr);
        V(q19) <+ transition((V(en) > vth && V(d20) > vth) ? vdd : 0.0, 0, tr, tr);
        V(q20) <+ transition((V(en) > vth && V(d21) > vth) ? vdd : 0.0, 0, tr, tr);
        V(q21) <+ transition((V(en) > vth && V(d22) > vth) ? vdd : 0.0, 0, tr, tr);
        V(q22) <+ transition((V(en) > vth && V(d23) > vth) ? vdd : 0.0, 0, tr, tr);
        V(q23) <+ transition((V(en) > vth && V(d24) > vth) ? vdd : 0.0, 0, tr, tr);
        V(q24) <+ transition((V(en) > vth && V(d25) > vth) ? vdd : 0.0, 0, tr, tr);
        V(q25) <+ transition((V(en) > vth && V(d26) > vth) ? vdd : 0.0, 0, tr, tr);
        V(q26) <+ transition((V(en) > vth && V(d27) > vth) ? vdd : 0.0, 0, tr, tr);
        V(q27) <+ transition((V(en) > vth && V(d28) > vth) ? vdd : 0.0, 0, tr, tr);
        V(q28) <+ transition((V(en) > vth && V(d29) > vth) ? vdd : 0.0, 0, tr, tr);
        V(q29) <+ transition((V(en) > vth && V(d30) > vth) ? vdd : 0.0, 0, tr, tr);
        V(q30) <+ transition((V(en) > vth && V(d31) > vth) ? vdd : 0.0, 0, tr, tr);
        V(q31) <+ transition((V(en) > vth && V(d32) > vth) ? vdd : 0.0, 0, tr, tr);
        V(q32) <+ transition((V(en) > vth && V(d33) > vth) ? vdd : 0.0, 0, tr, tr);
        V(q33) <+ transition((V(en) > vth && V(d34) > vth) ? vdd : 0.0, 0, tr, tr);
        V(q34) <+ transition((V(en) > vth && V(d35) > vth) ? vdd : 0.0, 0, tr, tr);
        V(q35) <+ transition((V(en) > vth && V(d36) > vth) ? vdd : 0.0, 0, tr, tr);
        V(q36) <+ transition((V(en) > vth && V(d37) > vth) ? vdd : 0.0, 0, tr, tr);
        V(q37) <+ transition((V(en) > vth && V(d38) > vth) ? vdd : 0.0, 0, tr, tr);
        V(q38) <+ transition((V(en) > vth && V(d39) > vth) ? vdd : 0.0, 0, tr, tr);
        V(q39) <+ transition((V(en) > vth && V(d40) > vth) ? vdd : 0.0, 0, tr, tr);
        V(q40) <+ transition((V(en) > vth && V(d41) > vth) ? vdd : 0.0, 0, tr, tr);
        V(q41) <+ transition((V(en) > vth && V(d42) > vth) ? vdd : 0.0, 0, tr, tr);
        V(q42) <+ transition((V(en) > vth && V(d43) > vth) ? vdd : 0.0, 0, tr, tr);
        V(q43) <+ transition((V(en) > vth && V(d44) > vth) ? vdd : 0.0, 0, tr, tr);
        V(q44) <+ transition((V(en) > vth && V(d45) > vth) ? vdd : 0.0, 0, tr, tr);
        V(q45) <+ transition((V(en) > vth && V(d46) > vth) ? vdd : 0.0, 0, tr, tr);
        V(q46) <+ transition((V(en) > vth && V(d47) > vth) ? vdd : 0.0, 0, tr, tr);
        V(q47) <+ transition((V(en) > vth && V(d48) > vth) ? vdd : 0.0, 0, tr, tr);
        V(q48) <+ transition((V(en) > vth && V(d49) > vth) ? vdd : 0.0, 0, tr, tr);
        V(q49) <+ transition((V(en) > vth && V(d50) > vth) ? vdd : 0.0, 0, tr, tr);
        V(q50) <+ transition((V(en) > vth && V(d51) > vth) ? vdd : 0.0, 0, tr, tr);
        V(q51) <+ transition((V(en) > vth && V(d52) > vth) ? vdd : 0.0, 0, tr, tr);
        V(q52) <+ transition((V(en) > vth && V(d53) > vth) ? vdd : 0.0, 0, tr, tr);
        V(q53) <+ transition((V(en) > vth && V(d54) > vth) ? vdd : 0.0, 0, tr, tr);
        V(q54) <+ transition((V(en) > vth && V(d55) > vth) ? vdd : 0.0, 0, tr, tr);
        V(q55) <+ transition((V(en) > vth && V(d56) > vth) ? vdd : 0.0, 0, tr, tr);
        V(q56) <+ transition((V(en) > vth && V(d57) > vth) ? vdd : 0.0, 0, tr, tr);
        V(q57) <+ transition((V(en) > vth && V(d58) > vth) ? vdd : 0.0, 0, tr, tr);
        V(q58) <+ transition((V(en) > vth && V(d59) > vth) ? vdd : 0.0, 0, tr, tr);
        V(q59) <+ transition((V(en) > vth && V(d60) > vth) ? vdd : 0.0, 0, tr, tr);
        V(q60) <+ transition((V(en) > vth && V(d61) > vth) ? vdd : 0.0, 0, tr, tr);
        V(q61) <+ transition((V(en) > vth && V(d62) > vth) ? vdd : 0.0, 0, tr, tr);
        V(q62) <+ transition((V(en) > vth && V(d63) > vth) ? vdd : 0.0, 0, tr, tr);
        V(q63) <+ transition((V(en) > vth && V(d64) > vth) ? vdd : 0.0, 0, tr, tr);
        V(q64) <+ transition((V(en) > vth && V(d65) > vth) ? vdd : 0.0, 0, tr, tr);
        V(q65) <+ transition((V(en) > vth && V(d66) > vth) ? vdd : 0.0, 0, tr, tr);
        V(q66) <+ transition((V(en) > vth && V(d67) > vth) ? vdd : 0.0, 0, tr, tr);
        V(q67) <+ transition((V(en) > vth && V(d68) > vth) ? vdd : 0.0, 0, tr, tr);
        V(q68) <+ transition((V(en) > vth && V(d69) > vth) ? vdd : 0.0, 0, tr, tr);
        V(q69) <+ transition((V(en) > vth && V(d70) > vth) ? vdd : 0.0, 0, tr, tr);
        V(q70) <+ transition((V(en) > vth && V(d71) > vth) ? vdd : 0.0, 0, tr, tr);
        V(q71) <+ transition((V(en) > vth && V(d72) > vth) ? vdd : 0.0, 0, tr, tr);
        V(q72) <+ transition((V(en) > vth && V(d73) > vth) ? vdd : 0.0, 0, tr, tr);
        V(q73) <+ transition((V(en) > vth && V(d74) > vth) ? vdd : 0.0, 0, tr, tr);
        V(q74) <+ transition((V(en) > vth && V(d75) > vth) ? vdd : 0.0, 0, tr, tr);
        V(q75) <+ transition((V(en) > vth && V(d76) > vth) ? vdd : 0.0, 0, tr, tr);
        V(q76) <+ transition((V(en) > vth && V(d77) > vth) ? vdd : 0.0, 0, tr, tr);
        V(q77) <+ transition((V(en) > vth && V(d78) > vth) ? vdd : 0.0, 0, tr, tr);
        V(q78) <+ transition((V(en) > vth && V(d79) > vth) ? vdd : 0.0, 0, tr, tr);
        V(q79) <+ transition((V(en) > vth && V(d80) > vth) ? vdd : 0.0, 0, tr, tr);
        V(q80) <+ transition((V(en) > vth && V(d81) > vth) ? vdd : 0.0, 0, tr, tr);
        V(q81) <+ transition((V(en) > vth && V(d82) > vth) ? vdd : 0.0, 0, tr, tr);
        V(q82) <+ transition((V(en) > vth && V(d83) > vth) ? vdd : 0.0, 0, tr, tr);
        V(q83) <+ transition((V(en) > vth && V(d84) > vth) ? vdd : 0.0, 0, tr, tr);
        V(q84) <+ transition((V(en) > vth && V(d85) > vth) ? vdd : 0.0, 0, tr, tr);
        V(q85) <+ transition((V(en) > vth && V(d86) > vth) ? vdd : 0.0, 0, tr, tr);
        V(q86) <+ transition((V(en) > vth && V(d87) > vth) ? vdd : 0.0, 0, tr, tr);
        V(q87) <+ transition((V(en) > vth && V(d88) > vth) ? vdd : 0.0, 0, tr, tr);
        V(q88) <+ transition((V(en) > vth && V(d89) > vth) ? vdd : 0.0, 0, tr, tr);
        V(q89) <+ transition((V(en) > vth && V(d90) > vth) ? vdd : 0.0, 0, tr, tr);
        V(q90) <+ transition((V(en) > vth && V(d91) > vth) ? vdd : 0.0, 0, tr, tr);
        V(q91) <+ transition((V(en) > vth && V(d92) > vth) ? vdd : 0.0, 0, tr, tr);
        V(q92) <+ transition((V(en) > vth && V(d93) > vth) ? vdd : 0.0, 0, tr, tr);
        V(q93) <+ transition((V(en) > vth && V(d94) > vth) ? vdd : 0.0, 0, tr, tr);
        V(q94) <+ transition((V(en) > vth && V(d95) > vth) ? vdd : 0.0, 0, tr, tr);
        V(q95) <+ transition((V(en) > vth && V(d96) > vth) ? vdd : 0.0, 0, tr, tr);
        V(q96) <+ transition((V(en) > vth && V(d97) > vth) ? vdd : 0.0, 0, tr, tr);
        V(q97) <+ transition((V(en) > vth && V(d98) > vth) ? vdd : 0.0, 0, tr, tr);
        V(q98) <+ transition((V(en) > vth && V(d99) > vth) ? vdd : 0.0, 0, tr, tr);
        V(q99) <+ transition((V(en) > vth && V(d100) > vth) ? vdd : 0.0, 0, tr, tr);
        V(q100) <+ transition((V(en) > vth && V(d101) > vth) ? vdd : 0.0, 0, tr, tr);
        V(q101) <+ transition((V(en) > vth && V(d102) > vth) ? vdd : 0.0, 0, tr, tr);
        V(q102) <+ transition((V(en) > vth && V(d103) > vth) ? vdd : 0.0, 0, tr, tr);
        V(q103) <+ transition((V(en) > vth && V(d104) > vth) ? vdd : 0.0, 0, tr, tr);
        V(q104) <+ transition((V(en) > vth && V(d105) > vth) ? vdd : 0.0, 0, tr, tr);
        V(q105) <+ transition((V(en) > vth && V(d106) > vth) ? vdd : 0.0, 0, tr, tr);
        V(q106) <+ transition((V(en) > vth && V(d107) > vth) ? vdd : 0.0, 0, tr, tr);
        V(q107) <+ transition((V(en) > vth && V(d108) > vth) ? vdd : 0.0, 0, tr, tr);
        V(q108) <+ transition((V(en) > vth && V(d109) > vth) ? vdd : 0.0, 0, tr, tr);
        V(q109) <+ transition((V(en) > vth && V(d110) > vth) ? vdd : 0.0, 0, tr, tr);
        V(q110) <+ transition((V(en) > vth && V(d111) > vth) ? vdd : 0.0, 0, tr, tr);
        V(q111) <+ transition((V(en) > vth && V(d112) > vth) ? vdd : 0.0, 0, tr, tr);
        V(q112) <+ transition((V(en) > vth && V(d113) > vth) ? vdd : 0.0, 0, tr, tr);
        V(q113) <+ transition((V(en) > vth && V(d114) > vth) ? vdd : 0.0, 0, tr, tr);
        V(q114) <+ transition((V(en) > vth && V(d115) > vth) ? vdd : 0.0, 0, tr, tr);
        V(q115) <+ transition((V(en) > vth && V(d116) > vth) ? vdd : 0.0, 0, tr, tr);
        V(q116) <+ transition((V(en) > vth && V(d117) > vth) ? vdd : 0.0, 0, tr, tr);
        V(q117) <+ transition((V(en) > vth && V(d118) > vth) ? vdd : 0.0, 0, tr, tr);
        V(q118) <+ transition((V(en) > vth && V(d119) > vth) ? vdd : 0.0, 0, tr, tr);
        V(q119) <+ transition((V(en) > vth && V(d120) > vth) ? vdd : 0.0, 0, tr, tr);
        V(q120) <+ transition((V(en) > vth && V(d121) > vth) ? vdd : 0.0, 0, tr, tr);
        V(q121) <+ transition((V(en) > vth && V(d122) > vth) ? vdd : 0.0, 0, tr, tr);
        V(q122) <+ transition((V(en) > vth && V(d123) > vth) ? vdd : 0.0, 0, tr, tr);
        V(q123) <+ transition((V(en) > vth && V(d124) > vth) ? vdd : 0.0, 0, tr, tr);
        V(q124) <+ transition((V(en) > vth && V(d125) > vth) ? vdd : 0.0, 0, tr, tr);
        V(q125) <+ transition((V(en) > vth && V(d126) > vth) ? vdd : 0.0, 0, tr, tr);
        V(q126) <+ transition((V(en) > vth && V(d127) > vth) ? vdd : 0.0, 0, tr, tr);
        V(q127) <+ transition((V(en) > vth && V(d0) > vth) ? vdd : 0.0, 0, tr, tr);
    end
endmodule
