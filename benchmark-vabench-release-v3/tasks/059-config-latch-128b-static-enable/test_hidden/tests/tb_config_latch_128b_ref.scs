simulator lang=spectre
global 0

ahdl_include "config_latch_128b.va"

Ven (en 0) vsource type=pwl wave=[ 0n 0.9 9n 0.9 10n 0.9 19n 0.9 20n 0 29n 0 30n 0.9 39n 0.9 40n 0.9 49n 0.9 50n 0 59n 0 60n 0.9 69n 0.9 70n 0.9 79n 0.9 80n 0 89n 0 90n 0.9 99n 0.9 100n 0.9 109n 0.9 ]
Vd127 (d127 0) vsource type=pwl wave=[ 0n 0 9n 0 10n 0 19n 0 20n 0 29n 0 30n 0 39n 0 40n 0 49n 0 50n 0 59n 0 60n 0 69n 0 70n 0 79n 0 80n 0 89n 0 90n 0 99n 0 100n 0 109n 0 ]
Vd126 (d126 0) vsource type=pwl wave=[ 0n 0 9n 0 10n 0 19n 0 20n 0 29n 0 30n 0 39n 0 40n 0 49n 0 50n 0 59n 0 60n 0 69n 0 70n 0 79n 0 80n 0 89n 0 90n 0 99n 0 100n 0 109n 0 ]
Vd125 (d125 0) vsource type=pwl wave=[ 0n 0 9n 0 10n 0 19n 0 20n 0 29n 0 30n 0 39n 0 40n 0 49n 0 50n 0 59n 0 60n 0 69n 0 70n 0 79n 0 80n 0 89n 0 90n 0 99n 0 100n 0 109n 0 ]
Vd124 (d124 0) vsource type=pwl wave=[ 0n 0 9n 0 10n 0 19n 0 20n 0 29n 0 30n 0 39n 0 40n 0 49n 0 50n 0 59n 0 60n 0 69n 0 70n 0 79n 0 80n 0 89n 0 90n 0 99n 0 100n 0 109n 0 ]
Vd123 (d123 0) vsource type=pwl wave=[ 0n 0 9n 0 10n 0 19n 0 20n 0 29n 0 30n 0 39n 0 40n 0 49n 0 50n 0 59n 0 60n 0 69n 0 70n 0 79n 0 80n 0 89n 0 90n 0 99n 0 100n 0 109n 0 ]
Vd122 (d122 0) vsource type=pwl wave=[ 0n 0 9n 0 10n 0 19n 0 20n 0 29n 0 30n 0 39n 0 40n 0 49n 0 50n 0 59n 0 60n 0 69n 0 70n 0 79n 0 80n 0 89n 0 90n 0 99n 0 100n 0 109n 0 ]
Vd121 (d121 0) vsource type=pwl wave=[ 0n 0 9n 0 10n 0 19n 0 20n 0 29n 0 30n 0 39n 0 40n 0 49n 0 50n 0 59n 0 60n 0 69n 0 70n 0 79n 0 80n 0 89n 0 90n 0 99n 0 100n 0 109n 0 ]
Vd120 (d120 0) vsource type=pwl wave=[ 0n 0 9n 0 10n 0 19n 0 20n 0 29n 0 30n 0 39n 0 40n 0 49n 0 50n 0 59n 0 60n 0 69n 0 70n 0 79n 0 80n 0 89n 0 90n 0 99n 0 100n 0 109n 0 ]
Vd119 (d119 0) vsource type=pwl wave=[ 0n 0 9n 0 10n 0 19n 0 20n 0 29n 0 30n 0 39n 0 40n 0 49n 0 50n 0 59n 0 60n 0 69n 0 70n 0 79n 0 80n 0 89n 0 90n 0 99n 0 100n 0 109n 0 ]
Vd118 (d118 0) vsource type=pwl wave=[ 0n 0 9n 0 10n 0 19n 0 20n 0 29n 0 30n 0 39n 0 40n 0 49n 0 50n 0 59n 0 60n 0 69n 0 70n 0 79n 0 80n 0 89n 0 90n 0 99n 0 100n 0 109n 0 ]
Vd117 (d117 0) vsource type=pwl wave=[ 0n 0 9n 0 10n 0 19n 0 20n 0 29n 0 30n 0 39n 0 40n 0 49n 0 50n 0 59n 0 60n 0 69n 0 70n 0 79n 0 80n 0 89n 0 90n 0 99n 0 100n 0 109n 0 ]
Vd116 (d116 0) vsource type=pwl wave=[ 0n 0 9n 0 10n 0 19n 0 20n 0 29n 0 30n 0 39n 0 40n 0 49n 0 50n 0 59n 0 60n 0 69n 0 70n 0 79n 0 80n 0 89n 0 90n 0 99n 0 100n 0 109n 0 ]
Vd115 (d115 0) vsource type=pwl wave=[ 0n 0 9n 0 10n 0 19n 0 20n 0 29n 0 30n 0 39n 0 40n 0 49n 0 50n 0 59n 0 60n 0 69n 0 70n 0 79n 0 80n 0 89n 0 90n 0 99n 0 100n 0 109n 0 ]
Vd114 (d114 0) vsource type=pwl wave=[ 0n 0 9n 0 10n 0 19n 0 20n 0 29n 0 30n 0 39n 0 40n 0 49n 0 50n 0 59n 0 60n 0 69n 0 70n 0 79n 0 80n 0 89n 0 90n 0 99n 0 100n 0 109n 0 ]
Vd113 (d113 0) vsource type=pwl wave=[ 0n 0 9n 0 10n 0 19n 0 20n 0 29n 0 30n 0 39n 0 40n 0 49n 0 50n 0 59n 0 60n 0 69n 0 70n 0 79n 0 80n 0 89n 0 90n 0 99n 0 100n 0 109n 0 ]
Vd112 (d112 0) vsource type=pwl wave=[ 0n 0 9n 0 10n 0 19n 0 20n 0 29n 0 30n 0 39n 0 40n 0 49n 0 50n 0 59n 0 60n 0 69n 0 70n 0 79n 0 80n 0 89n 0 90n 0 99n 0 100n 0 109n 0 ]
Vd111 (d111 0) vsource type=pwl wave=[ 0n 0 9n 0 10n 0 19n 0 20n 0 29n 0 30n 0 39n 0 40n 0 49n 0 50n 0 59n 0 60n 0 69n 0 70n 0 79n 0 80n 0 89n 0 90n 0 99n 0 100n 0 109n 0 ]
Vd110 (d110 0) vsource type=pwl wave=[ 0n 0 9n 0 10n 0 19n 0 20n 0 29n 0 30n 0 39n 0 40n 0 49n 0 50n 0 59n 0 60n 0 69n 0 70n 0 79n 0 80n 0 89n 0 90n 0 99n 0 100n 0 109n 0 ]
Vd109 (d109 0) vsource type=pwl wave=[ 0n 0 9n 0 10n 0 19n 0 20n 0 29n 0 30n 0 39n 0 40n 0 49n 0 50n 0 59n 0 60n 0 69n 0 70n 0 79n 0 80n 0 89n 0 90n 0 99n 0 100n 0 109n 0 ]
Vd108 (d108 0) vsource type=pwl wave=[ 0n 0 9n 0 10n 0 19n 0 20n 0 29n 0 30n 0 39n 0 40n 0 49n 0 50n 0 59n 0 60n 0 69n 0 70n 0 79n 0 80n 0 89n 0 90n 0 99n 0 100n 0 109n 0 ]
Vd107 (d107 0) vsource type=pwl wave=[ 0n 0 9n 0 10n 0 19n 0 20n 0 29n 0 30n 0 39n 0 40n 0 49n 0 50n 0 59n 0 60n 0 69n 0 70n 0 79n 0 80n 0 89n 0 90n 0 99n 0 100n 0 109n 0 ]
Vd106 (d106 0) vsource type=pwl wave=[ 0n 0 9n 0 10n 0 19n 0 20n 0 29n 0 30n 0 39n 0 40n 0 49n 0 50n 0 59n 0 60n 0 69n 0 70n 0 79n 0 80n 0 89n 0 90n 0 99n 0 100n 0 109n 0 ]
Vd105 (d105 0) vsource type=pwl wave=[ 0n 0 9n 0 10n 0 19n 0 20n 0 29n 0 30n 0 39n 0 40n 0 49n 0 50n 0 59n 0 60n 0 69n 0 70n 0 79n 0 80n 0 89n 0 90n 0 99n 0 100n 0 109n 0 ]
Vd104 (d104 0) vsource type=pwl wave=[ 0n 0 9n 0 10n 0 19n 0 20n 0 29n 0 30n 0 39n 0 40n 0 49n 0 50n 0 59n 0 60n 0 69n 0 70n 0 79n 0 80n 0 89n 0 90n 0 99n 0 100n 0 109n 0 ]
Vd103 (d103 0) vsource type=pwl wave=[ 0n 0 9n 0 10n 0 19n 0 20n 0 29n 0 30n 0 39n 0 40n 0 49n 0 50n 0 59n 0 60n 0 69n 0 70n 0 79n 0 80n 0 89n 0 90n 0 99n 0 100n 0 109n 0 ]
Vd102 (d102 0) vsource type=pwl wave=[ 0n 0 9n 0 10n 0 19n 0 20n 0 29n 0 30n 0 39n 0 40n 0 49n 0 50n 0 59n 0 60n 0 69n 0 70n 0 79n 0 80n 0 89n 0 90n 0 99n 0 100n 0 109n 0 ]
Vd101 (d101 0) vsource type=pwl wave=[ 0n 0 9n 0 10n 0 19n 0 20n 0 29n 0 30n 0 39n 0 40n 0 49n 0 50n 0 59n 0 60n 0 69n 0 70n 0 79n 0 80n 0 89n 0 90n 0 99n 0 100n 0 109n 0 ]
Vd100 (d100 0) vsource type=pwl wave=[ 0n 0 9n 0 10n 0 19n 0 20n 0 29n 0 30n 0 39n 0 40n 0 49n 0 50n 0 59n 0 60n 0 69n 0 70n 0 79n 0 80n 0 89n 0 90n 0 99n 0 100n 0 109n 0 ]
Vd99 (d99 0) vsource type=pwl wave=[ 0n 0 9n 0 10n 0 19n 0 20n 0 29n 0 30n 0 39n 0 40n 0 49n 0 50n 0 59n 0 60n 0 69n 0 70n 0 79n 0 80n 0 89n 0 90n 0 99n 0 100n 0 109n 0 ]
Vd98 (d98 0) vsource type=pwl wave=[ 0n 0 9n 0 10n 0 19n 0 20n 0 29n 0 30n 0 39n 0 40n 0 49n 0 50n 0 59n 0 60n 0 69n 0 70n 0 79n 0 80n 0 89n 0 90n 0 99n 0 100n 0 109n 0 ]
Vd97 (d97 0) vsource type=pwl wave=[ 0n 0 9n 0 10n 0 19n 0 20n 0 29n 0 30n 0 39n 0 40n 0 49n 0 50n 0 59n 0 60n 0 69n 0 70n 0 79n 0 80n 0 89n 0 90n 0 99n 0 100n 0 109n 0 ]
Vd96 (d96 0) vsource type=pwl wave=[ 0n 0 9n 0 10n 0 19n 0 20n 0 29n 0 30n 0 39n 0 40n 0 49n 0 50n 0 59n 0 60n 0 69n 0 70n 0 79n 0 80n 0 89n 0 90n 0 99n 0 100n 0 109n 0 ]
Vd95 (d95 0) vsource type=pwl wave=[ 0n 0 9n 0 10n 0 19n 0 20n 0 29n 0 30n 0 39n 0 40n 0 49n 0 50n 0 59n 0 60n 0 69n 0 70n 0 79n 0 80n 0 89n 0 90n 0 99n 0 100n 0 109n 0 ]
Vd94 (d94 0) vsource type=pwl wave=[ 0n 0 9n 0 10n 0 19n 0 20n 0 29n 0 30n 0 39n 0 40n 0 49n 0 50n 0 59n 0 60n 0 69n 0 70n 0 79n 0 80n 0 89n 0 90n 0 99n 0 100n 0 109n 0 ]
Vd93 (d93 0) vsource type=pwl wave=[ 0n 0 9n 0 10n 0 19n 0 20n 0 29n 0 30n 0 39n 0 40n 0 49n 0 50n 0 59n 0 60n 0 69n 0 70n 0 79n 0 80n 0 89n 0 90n 0 99n 0 100n 0 109n 0 ]
Vd92 (d92 0) vsource type=pwl wave=[ 0n 0 9n 0 10n 0 19n 0 20n 0 29n 0 30n 0 39n 0 40n 0 49n 0 50n 0 59n 0 60n 0 69n 0 70n 0 79n 0 80n 0 89n 0 90n 0 99n 0 100n 0 109n 0 ]
Vd91 (d91 0) vsource type=pwl wave=[ 0n 0 9n 0 10n 0 19n 0 20n 0 29n 0 30n 0 39n 0 40n 0 49n 0 50n 0 59n 0 60n 0 69n 0 70n 0 79n 0 80n 0 89n 0 90n 0 99n 0 100n 0 109n 0 ]
Vd90 (d90 0) vsource type=pwl wave=[ 0n 0 9n 0 10n 0 19n 0 20n 0 29n 0 30n 0 39n 0 40n 0 49n 0 50n 0 59n 0 60n 0 69n 0 70n 0 79n 0 80n 0 89n 0 90n 0 99n 0 100n 0 109n 0 ]
Vd89 (d89 0) vsource type=pwl wave=[ 0n 0 9n 0 10n 0 19n 0 20n 0 29n 0 30n 0 39n 0 40n 0 49n 0 50n 0 59n 0 60n 0 69n 0 70n 0 79n 0 80n 0 89n 0 90n 0 99n 0 100n 0 109n 0 ]
Vd88 (d88 0) vsource type=pwl wave=[ 0n 0 9n 0 10n 0 19n 0 20n 0 29n 0 30n 0 39n 0 40n 0 49n 0 50n 0 59n 0 60n 0 69n 0 70n 0 79n 0 80n 0 89n 0 90n 0 99n 0 100n 0 109n 0 ]
Vd87 (d87 0) vsource type=pwl wave=[ 0n 0 9n 0 10n 0 19n 0 20n 0 29n 0 30n 0 39n 0 40n 0 49n 0 50n 0 59n 0 60n 0 69n 0 70n 0 79n 0 80n 0 89n 0 90n 0 99n 0 100n 0 109n 0 ]
Vd86 (d86 0) vsource type=pwl wave=[ 0n 0 9n 0 10n 0 19n 0 20n 0 29n 0 30n 0 39n 0 40n 0 49n 0 50n 0 59n 0 60n 0 69n 0 70n 0 79n 0 80n 0 89n 0 90n 0 99n 0 100n 0 109n 0 ]
Vd85 (d85 0) vsource type=pwl wave=[ 0n 0 9n 0 10n 0 19n 0 20n 0 29n 0 30n 0 39n 0 40n 0 49n 0 50n 0 59n 0 60n 0 69n 0 70n 0 79n 0 80n 0 89n 0 90n 0 99n 0 100n 0 109n 0 ]
Vd84 (d84 0) vsource type=pwl wave=[ 0n 0 9n 0 10n 0 19n 0 20n 0 29n 0 30n 0 39n 0 40n 0 49n 0 50n 0 59n 0 60n 0 69n 0 70n 0 79n 0 80n 0 89n 0 90n 0 99n 0 100n 0 109n 0 ]
Vd83 (d83 0) vsource type=pwl wave=[ 0n 0 9n 0 10n 0 19n 0 20n 0 29n 0 30n 0 39n 0 40n 0 49n 0 50n 0 59n 0 60n 0 69n 0 70n 0 79n 0 80n 0 89n 0 90n 0 99n 0 100n 0 109n 0 ]
Vd82 (d82 0) vsource type=pwl wave=[ 0n 0 9n 0 10n 0 19n 0 20n 0 29n 0 30n 0 39n 0 40n 0 49n 0 50n 0 59n 0 60n 0 69n 0 70n 0 79n 0 80n 0 89n 0 90n 0 99n 0 100n 0 109n 0 ]
Vd81 (d81 0) vsource type=pwl wave=[ 0n 0 9n 0 10n 0 19n 0 20n 0 29n 0 30n 0 39n 0 40n 0 49n 0 50n 0 59n 0 60n 0 69n 0 70n 0 79n 0 80n 0 89n 0 90n 0 99n 0 100n 0 109n 0 ]
Vd80 (d80 0) vsource type=pwl wave=[ 0n 0 9n 0 10n 0 19n 0 20n 0 29n 0 30n 0 39n 0 40n 0 49n 0 50n 0 59n 0 60n 0 69n 0 70n 0 79n 0 80n 0 89n 0 90n 0 99n 0 100n 0 109n 0 ]
Vd79 (d79 0) vsource type=pwl wave=[ 0n 0 9n 0 10n 0 19n 0 20n 0 29n 0 30n 0 39n 0 40n 0 49n 0 50n 0 59n 0 60n 0 69n 0 70n 0 79n 0 80n 0 89n 0 90n 0 99n 0 100n 0 109n 0 ]
Vd78 (d78 0) vsource type=pwl wave=[ 0n 0 9n 0 10n 0 19n 0 20n 0 29n 0 30n 0 39n 0 40n 0 49n 0 50n 0 59n 0 60n 0 69n 0 70n 0 79n 0 80n 0 89n 0 90n 0 99n 0 100n 0 109n 0 ]
Vd77 (d77 0) vsource type=pwl wave=[ 0n 0 9n 0 10n 0 19n 0 20n 0 29n 0 30n 0 39n 0 40n 0 49n 0 50n 0 59n 0 60n 0 69n 0 70n 0 79n 0 80n 0 89n 0 90n 0 99n 0 100n 0 109n 0 ]
Vd76 (d76 0) vsource type=pwl wave=[ 0n 0 9n 0 10n 0 19n 0 20n 0 29n 0 30n 0 39n 0 40n 0 49n 0 50n 0 59n 0 60n 0 69n 0 70n 0 79n 0 80n 0 89n 0 90n 0 99n 0 100n 0 109n 0 ]
Vd75 (d75 0) vsource type=pwl wave=[ 0n 0 9n 0 10n 0 19n 0 20n 0 29n 0 30n 0 39n 0 40n 0 49n 0 50n 0 59n 0 60n 0 69n 0 70n 0 79n 0 80n 0 89n 0 90n 0 99n 0 100n 0 109n 0 ]
Vd74 (d74 0) vsource type=pwl wave=[ 0n 0 9n 0 10n 0 19n 0 20n 0 29n 0 30n 0 39n 0 40n 0 49n 0 50n 0 59n 0 60n 0 69n 0 70n 0 79n 0 80n 0 89n 0 90n 0 99n 0 100n 0 109n 0 ]
Vd73 (d73 0) vsource type=pwl wave=[ 0n 0 9n 0 10n 0 19n 0 20n 0 29n 0 30n 0 39n 0 40n 0 49n 0 50n 0 59n 0 60n 0 69n 0 70n 0 79n 0 80n 0 89n 0 90n 0 99n 0 100n 0 109n 0 ]
Vd72 (d72 0) vsource type=pwl wave=[ 0n 0 9n 0 10n 0 19n 0 20n 0 29n 0 30n 0 39n 0 40n 0 49n 0 50n 0 59n 0 60n 0 69n 0 70n 0 79n 0 80n 0 89n 0 90n 0 99n 0 100n 0 109n 0 ]
Vd71 (d71 0) vsource type=pwl wave=[ 0n 0 9n 0 10n 0 19n 0 20n 0 29n 0 30n 0 39n 0 40n 0 49n 0 50n 0 59n 0 60n 0 69n 0 70n 0 79n 0 80n 0 89n 0 90n 0 99n 0 100n 0 109n 0 ]
Vd70 (d70 0) vsource type=pwl wave=[ 0n 0 9n 0 10n 0 19n 0 20n 0 29n 0 30n 0 39n 0 40n 0 49n 0 50n 0 59n 0 60n 0 69n 0 70n 0 79n 0 80n 0 89n 0 90n 0 99n 0 100n 0 109n 0 ]
Vd69 (d69 0) vsource type=pwl wave=[ 0n 0 9n 0 10n 0 19n 0 20n 0 29n 0 30n 0 39n 0 40n 0 49n 0 50n 0 59n 0 60n 0 69n 0 70n 0 79n 0 80n 0 89n 0 90n 0 99n 0 100n 0 109n 0 ]
Vd68 (d68 0) vsource type=pwl wave=[ 0n 0 9n 0 10n 0 19n 0 20n 0 29n 0 30n 0 39n 0 40n 0 49n 0 50n 0 59n 0 60n 0 69n 0 70n 0 79n 0 80n 0 89n 0 90n 0 99n 0 100n 0 109n 0 ]
Vd67 (d67 0) vsource type=pwl wave=[ 0n 0 9n 0 10n 0 19n 0 20n 0 29n 0 30n 0 39n 0 40n 0 49n 0 50n 0 59n 0 60n 0 69n 0 70n 0 79n 0 80n 0 89n 0 90n 0 99n 0 100n 0 109n 0 ]
Vd66 (d66 0) vsource type=pwl wave=[ 0n 0 9n 0 10n 0 19n 0 20n 0 29n 0 30n 0 39n 0 40n 0 49n 0 50n 0 59n 0 60n 0 69n 0 70n 0 79n 0 80n 0 89n 0 90n 0 99n 0 100n 0 109n 0 ]
Vd65 (d65 0) vsource type=pwl wave=[ 0n 0 9n 0 10n 0 19n 0 20n 0 29n 0 30n 0 39n 0 40n 0 49n 0 50n 0 59n 0 60n 0 69n 0 70n 0 79n 0 80n 0 89n 0 90n 0 99n 0 100n 0 109n 0 ]
Vd64 (d64 0) vsource type=pwl wave=[ 0n 0 9n 0 10n 0 19n 0 20n 0 29n 0 30n 0 39n 0 40n 0 49n 0 50n 0 59n 0 60n 0 69n 0 70n 0 79n 0 80n 0 89n 0 90n 0 99n 0 100n 0 109n 0 ]
Vd63 (d63 0) vsource type=pwl wave=[ 0n 0 9n 0 10n 0 19n 0 20n 0 29n 0 30n 0 39n 0 40n 0 49n 0 50n 0 59n 0 60n 0 69n 0 70n 0 79n 0 80n 0 89n 0 90n 0 99n 0 100n 0 109n 0 ]
Vd62 (d62 0) vsource type=pwl wave=[ 0n 0 9n 0 10n 0 19n 0 20n 0 29n 0 30n 0 39n 0 40n 0 49n 0 50n 0 59n 0 60n 0 69n 0 70n 0 79n 0 80n 0 89n 0 90n 0 99n 0 100n 0 109n 0 ]
Vd61 (d61 0) vsource type=pwl wave=[ 0n 0 9n 0 10n 0 19n 0 20n 0 29n 0 30n 0 39n 0 40n 0 49n 0 50n 0 59n 0 60n 0 69n 0 70n 0 79n 0 80n 0 89n 0 90n 0 99n 0 100n 0 109n 0 ]
Vd60 (d60 0) vsource type=pwl wave=[ 0n 0 9n 0 10n 0 19n 0 20n 0 29n 0 30n 0 39n 0 40n 0 49n 0 50n 0 59n 0 60n 0 69n 0 70n 0 79n 0 80n 0 89n 0 90n 0 99n 0 100n 0 109n 0 ]
Vd59 (d59 0) vsource type=pwl wave=[ 0n 0 9n 0 10n 0 19n 0 20n 0 29n 0 30n 0 39n 0 40n 0 49n 0 50n 0 59n 0 60n 0 69n 0 70n 0 79n 0 80n 0 89n 0 90n 0 99n 0 100n 0 109n 0 ]
Vd58 (d58 0) vsource type=pwl wave=[ 0n 0 9n 0 10n 0 19n 0 20n 0 29n 0 30n 0 39n 0 40n 0 49n 0 50n 0 59n 0 60n 0 69n 0 70n 0 79n 0 80n 0 89n 0 90n 0 99n 0 100n 0 109n 0 ]
Vd57 (d57 0) vsource type=pwl wave=[ 0n 0 9n 0 10n 0 19n 0 20n 0 29n 0 30n 0 39n 0 40n 0 49n 0 50n 0 59n 0 60n 0 69n 0 70n 0 79n 0 80n 0 89n 0 90n 0 99n 0 100n 0 109n 0 ]
Vd56 (d56 0) vsource type=pwl wave=[ 0n 0 9n 0 10n 0 19n 0 20n 0 29n 0 30n 0 39n 0 40n 0 49n 0 50n 0 59n 0 60n 0 69n 0 70n 0 79n 0 80n 0 89n 0 90n 0 99n 0 100n 0 109n 0 ]
Vd55 (d55 0) vsource type=pwl wave=[ 0n 0 9n 0 10n 0 19n 0 20n 0 29n 0 30n 0 39n 0 40n 0 49n 0 50n 0 59n 0 60n 0 69n 0 70n 0 79n 0 80n 0 89n 0 90n 0 99n 0 100n 0 109n 0 ]
Vd54 (d54 0) vsource type=pwl wave=[ 0n 0 9n 0 10n 0 19n 0 20n 0 29n 0 30n 0 39n 0 40n 0 49n 0 50n 0 59n 0 60n 0 69n 0 70n 0 79n 0 80n 0 89n 0 90n 0 99n 0 100n 0 109n 0 ]
Vd53 (d53 0) vsource type=pwl wave=[ 0n 0 9n 0 10n 0 19n 0 20n 0 29n 0 30n 0 39n 0 40n 0 49n 0 50n 0 59n 0 60n 0 69n 0 70n 0 79n 0 80n 0 89n 0 90n 0 99n 0 100n 0 109n 0 ]
Vd52 (d52 0) vsource type=pwl wave=[ 0n 0 9n 0 10n 0 19n 0 20n 0 29n 0 30n 0 39n 0 40n 0 49n 0 50n 0 59n 0 60n 0 69n 0 70n 0 79n 0 80n 0 89n 0 90n 0 99n 0 100n 0 109n 0 ]
Vd51 (d51 0) vsource type=pwl wave=[ 0n 0 9n 0 10n 0 19n 0 20n 0 29n 0 30n 0 39n 0 40n 0 49n 0 50n 0 59n 0 60n 0 69n 0 70n 0 79n 0 80n 0 89n 0 90n 0 99n 0 100n 0 109n 0 ]
Vd50 (d50 0) vsource type=pwl wave=[ 0n 0 9n 0 10n 0 19n 0 20n 0 29n 0 30n 0 39n 0 40n 0 49n 0 50n 0 59n 0 60n 0 69n 0 70n 0 79n 0 80n 0 89n 0 90n 0 99n 0 100n 0 109n 0 ]
Vd49 (d49 0) vsource type=pwl wave=[ 0n 0 9n 0 10n 0 19n 0 20n 0 29n 0 30n 0 39n 0 40n 0 49n 0 50n 0 59n 0 60n 0 69n 0 70n 0 79n 0 80n 0 89n 0 90n 0 99n 0 100n 0 109n 0 ]
Vd48 (d48 0) vsource type=pwl wave=[ 0n 0 9n 0 10n 0 19n 0 20n 0 29n 0 30n 0 39n 0 40n 0 49n 0 50n 0 59n 0 60n 0 69n 0 70n 0 79n 0 80n 0 89n 0 90n 0 99n 0 100n 0 109n 0 ]
Vd47 (d47 0) vsource type=pwl wave=[ 0n 0 9n 0 10n 0 19n 0 20n 0 29n 0 30n 0 39n 0 40n 0 49n 0 50n 0 59n 0 60n 0 69n 0 70n 0 79n 0 80n 0 89n 0 90n 0 99n 0 100n 0 109n 0 ]
Vd46 (d46 0) vsource type=pwl wave=[ 0n 0 9n 0 10n 0 19n 0 20n 0 29n 0 30n 0 39n 0 40n 0 49n 0 50n 0 59n 0 60n 0 69n 0 70n 0 79n 0 80n 0 89n 0 90n 0 99n 0 100n 0 109n 0 ]
Vd45 (d45 0) vsource type=pwl wave=[ 0n 0 9n 0 10n 0 19n 0 20n 0 29n 0 30n 0 39n 0 40n 0 49n 0 50n 0 59n 0 60n 0 69n 0 70n 0 79n 0 80n 0 89n 0 90n 0 99n 0 100n 0 109n 0 ]
Vd44 (d44 0) vsource type=pwl wave=[ 0n 0 9n 0 10n 0 19n 0 20n 0 29n 0 30n 0 39n 0 40n 0 49n 0 50n 0 59n 0 60n 0 69n 0 70n 0 79n 0 80n 0 89n 0 90n 0 99n 0 100n 0 109n 0 ]
Vd43 (d43 0) vsource type=pwl wave=[ 0n 0 9n 0 10n 0 19n 0 20n 0 29n 0 30n 0 39n 0 40n 0 49n 0 50n 0 59n 0 60n 0 69n 0 70n 0 79n 0 80n 0 89n 0 90n 0 99n 0 100n 0 109n 0 ]
Vd42 (d42 0) vsource type=pwl wave=[ 0n 0 9n 0 10n 0 19n 0 20n 0 29n 0 30n 0 39n 0 40n 0 49n 0 50n 0 59n 0 60n 0 69n 0 70n 0 79n 0 80n 0 89n 0 90n 0 99n 0 100n 0 109n 0 ]
Vd41 (d41 0) vsource type=pwl wave=[ 0n 0 9n 0 10n 0 19n 0 20n 0 29n 0 30n 0 39n 0 40n 0 49n 0 50n 0 59n 0 60n 0 69n 0 70n 0 79n 0 80n 0 89n 0 90n 0 99n 0 100n 0 109n 0 ]
Vd40 (d40 0) vsource type=pwl wave=[ 0n 0 9n 0 10n 0 19n 0 20n 0 29n 0 30n 0 39n 0 40n 0 49n 0 50n 0 59n 0 60n 0 69n 0 70n 0 79n 0 80n 0 89n 0 90n 0 99n 0 100n 0 109n 0 ]
Vd39 (d39 0) vsource type=pwl wave=[ 0n 0 9n 0 10n 0 19n 0 20n 0 29n 0 30n 0 39n 0 40n 0 49n 0 50n 0 59n 0 60n 0 69n 0 70n 0 79n 0 80n 0 89n 0 90n 0 99n 0 100n 0 109n 0 ]
Vd38 (d38 0) vsource type=pwl wave=[ 0n 0 9n 0 10n 0 19n 0 20n 0 29n 0 30n 0 39n 0 40n 0 49n 0 50n 0 59n 0 60n 0 69n 0 70n 0 79n 0 80n 0 89n 0 90n 0 99n 0 100n 0 109n 0 ]
Vd37 (d37 0) vsource type=pwl wave=[ 0n 0 9n 0 10n 0 19n 0 20n 0 29n 0 30n 0 39n 0 40n 0 49n 0 50n 0 59n 0 60n 0 69n 0 70n 0 79n 0 80n 0 89n 0 90n 0 99n 0 100n 0 109n 0 ]
Vd36 (d36 0) vsource type=pwl wave=[ 0n 0 9n 0 10n 0 19n 0 20n 0 29n 0 30n 0 39n 0 40n 0 49n 0 50n 0 59n 0 60n 0 69n 0 70n 0 79n 0 80n 0 89n 0 90n 0 99n 0 100n 0 109n 0 ]
Vd35 (d35 0) vsource type=pwl wave=[ 0n 0 9n 0 10n 0 19n 0 20n 0 29n 0 30n 0 39n 0 40n 0 49n 0 50n 0 59n 0 60n 0 69n 0 70n 0 79n 0 80n 0 89n 0 90n 0 99n 0 100n 0 109n 0 ]
Vd34 (d34 0) vsource type=pwl wave=[ 0n 0 9n 0 10n 0 19n 0 20n 0 29n 0 30n 0 39n 0 40n 0 49n 0 50n 0 59n 0 60n 0 69n 0 70n 0 79n 0 80n 0 89n 0 90n 0 99n 0 100n 0 109n 0 ]
Vd33 (d33 0) vsource type=pwl wave=[ 0n 0 9n 0 10n 0 19n 0 20n 0 29n 0 30n 0 39n 0 40n 0 49n 0 50n 0 59n 0 60n 0 69n 0 70n 0 79n 0 80n 0 89n 0 90n 0 99n 0 100n 0 109n 0 ]
Vd32 (d32 0) vsource type=pwl wave=[ 0n 0 9n 0 10n 0 19n 0 20n 0 29n 0 30n 0 39n 0 40n 0 49n 0 50n 0 59n 0 60n 0 69n 0 70n 0 79n 0 80n 0 89n 0 90n 0 99n 0 100n 0 109n 0 ]
Vd31 (d31 0) vsource type=pwl wave=[ 0n 0 9n 0 10n 0 19n 0 20n 0 29n 0 30n 0 39n 0 40n 0 49n 0 50n 0 59n 0 60n 0 69n 0 70n 0 79n 0 80n 0 89n 0 90n 0 99n 0 100n 0 109n 0 ]
Vd30 (d30 0) vsource type=pwl wave=[ 0n 0 9n 0 10n 0 19n 0 20n 0 29n 0 30n 0 39n 0 40n 0 49n 0 50n 0 59n 0 60n 0 69n 0 70n 0 79n 0 80n 0 89n 0 90n 0 99n 0 100n 0 109n 0 ]
Vd29 (d29 0) vsource type=pwl wave=[ 0n 0 9n 0 10n 0 19n 0 20n 0 29n 0 30n 0 39n 0 40n 0 49n 0 50n 0 59n 0 60n 0 69n 0 70n 0 79n 0 80n 0 89n 0 90n 0 99n 0 100n 0 109n 0 ]
Vd28 (d28 0) vsource type=pwl wave=[ 0n 0 9n 0 10n 0 19n 0 20n 0 29n 0 30n 0 39n 0 40n 0 49n 0 50n 0 59n 0 60n 0 69n 0 70n 0 79n 0 80n 0 89n 0 90n 0 99n 0 100n 0 109n 0 ]
Vd27 (d27 0) vsource type=pwl wave=[ 0n 0 9n 0 10n 0 19n 0 20n 0 29n 0 30n 0 39n 0 40n 0 49n 0 50n 0 59n 0 60n 0 69n 0 70n 0 79n 0 80n 0 89n 0 90n 0 99n 0 100n 0 109n 0 ]
Vd26 (d26 0) vsource type=pwl wave=[ 0n 0 9n 0 10n 0 19n 0 20n 0 29n 0 30n 0 39n 0 40n 0 49n 0 50n 0 59n 0 60n 0 69n 0 70n 0 79n 0 80n 0 89n 0 90n 0 99n 0 100n 0 109n 0 ]
Vd25 (d25 0) vsource type=pwl wave=[ 0n 0 9n 0 10n 0 19n 0 20n 0 29n 0 30n 0 39n 0 40n 0 49n 0 50n 0 59n 0 60n 0 69n 0 70n 0 79n 0 80n 0 89n 0 90n 0 99n 0 100n 0 109n 0 ]
Vd24 (d24 0) vsource type=pwl wave=[ 0n 0 9n 0 10n 0 19n 0 20n 0 29n 0 30n 0 39n 0 40n 0 49n 0 50n 0 59n 0 60n 0 69n 0 70n 0 79n 0 80n 0 89n 0 90n 0 99n 0 100n 0 109n 0 ]
Vd23 (d23 0) vsource type=pwl wave=[ 0n 0 9n 0 10n 0 19n 0 20n 0 29n 0 30n 0 39n 0 40n 0 49n 0 50n 0 59n 0 60n 0 69n 0 70n 0 79n 0 80n 0 89n 0 90n 0 99n 0 100n 0 109n 0 ]
Vd22 (d22 0) vsource type=pwl wave=[ 0n 0 9n 0 10n 0 19n 0 20n 0 29n 0 30n 0 39n 0 40n 0 49n 0 50n 0 59n 0 60n 0 69n 0 70n 0 79n 0 80n 0 89n 0 90n 0 99n 0 100n 0 109n 0 ]
Vd21 (d21 0) vsource type=pwl wave=[ 0n 0 9n 0 10n 0 19n 0 20n 0 29n 0 30n 0 39n 0 40n 0 49n 0 50n 0 59n 0 60n 0 69n 0 70n 0 79n 0 80n 0 89n 0 90n 0 99n 0 100n 0 109n 0 ]
Vd20 (d20 0) vsource type=pwl wave=[ 0n 0 9n 0 10n 0 19n 0 20n 0 29n 0 30n 0 39n 0 40n 0 49n 0 50n 0 59n 0 60n 0 69n 0 70n 0 79n 0 80n 0 89n 0 90n 0 99n 0 100n 0 109n 0 ]
Vd19 (d19 0) vsource type=pwl wave=[ 0n 0 9n 0 10n 0 19n 0 20n 0 29n 0 30n 0 39n 0 40n 0 49n 0 50n 0 59n 0 60n 0 69n 0 70n 0 79n 0 80n 0 89n 0 90n 0 99n 0 100n 0 109n 0 ]
Vd18 (d18 0) vsource type=pwl wave=[ 0n 0 9n 0 10n 0 19n 0 20n 0 29n 0 30n 0 39n 0 40n 0 49n 0 50n 0 59n 0 60n 0 69n 0 70n 0 79n 0 80n 0 89n 0 90n 0 99n 0 100n 0 109n 0 ]
Vd17 (d17 0) vsource type=pwl wave=[ 0n 0 9n 0 10n 0 19n 0 20n 0 29n 0 30n 0 39n 0 40n 0 49n 0 50n 0 59n 0 60n 0 69n 0 70n 0 79n 0 80n 0 89n 0 90n 0 99n 0 100n 0 109n 0 ]
Vd16 (d16 0) vsource type=pwl wave=[ 0n 0 9n 0 10n 0 19n 0 20n 0 29n 0 30n 0 39n 0 40n 0 49n 0 50n 0 59n 0 60n 0 69n 0 70n 0 79n 0 80n 0 89n 0 90n 0 99n 0 100n 0 109n 0 ]
Vd15 (d15 0) vsource type=pwl wave=[ 0n 0 9n 0 10n 0 19n 0 20n 0 29n 0 30n 0 39n 0 40n 0 49n 0 50n 0 59n 0 60n 0 69n 0 70n 0 79n 0 80n 0 89n 0 90n 0 99n 0 100n 0 109n 0 ]
Vd14 (d14 0) vsource type=pwl wave=[ 0n 0 9n 0 10n 0 19n 0 20n 0 29n 0 30n 0 39n 0 40n 0 49n 0 50n 0 59n 0 60n 0 69n 0 70n 0 79n 0 80n 0 89n 0 90n 0 99n 0 100n 0 109n 0 ]
Vd13 (d13 0) vsource type=pwl wave=[ 0n 0 9n 0 10n 0 19n 0 20n 0 29n 0 30n 0 39n 0 40n 0 49n 0 50n 0 59n 0 60n 0 69n 0 70n 0 79n 0 80n 0 89n 0 90n 0 99n 0 100n 0 109n 0 ]
Vd12 (d12 0) vsource type=pwl wave=[ 0n 0 9n 0 10n 0 19n 0 20n 0 29n 0 30n 0 39n 0 40n 0 49n 0 50n 0 59n 0 60n 0 69n 0 70n 0 79n 0 80n 0 89n 0 90n 0 99n 0 100n 0 109n 0 ]
Vd11 (d11 0) vsource type=pwl wave=[ 0n 0 9n 0 10n 0 19n 0 20n 0 29n 0 30n 0 39n 0 40n 0 49n 0 50n 0 59n 0 60n 0 69n 0 70n 0 79n 0 80n 0 89n 0 90n 0 99n 0 100n 0 109n 0 ]
Vd10 (d10 0) vsource type=pwl wave=[ 0n 0 9n 0 10n 0 19n 0 20n 0 29n 0 30n 0 39n 0 40n 0 49n 0 50n 0 59n 0 60n 0 69n 0 70n 0 79n 0 80n 0 89n 0 90n 0 99n 0 100n 0 109n 0 ]
Vd9 (d9 0) vsource type=pwl wave=[ 0n 0 9n 0 10n 0 19n 0 20n 0 29n 0 30n 0 39n 0 40n 0 49n 0 50n 0 59n 0 60n 0 69n 0 70n 0 79n 0 80n 0 89n 0 90n 0 99n 0 100n 0 109n 0 ]
Vd8 (d8 0) vsource type=pwl wave=[ 0n 0 9n 0 10n 0 19n 0 20n 0 29n 0 30n 0 39n 0 40n 0 49n 0 50n 0 59n 0 60n 0 69n 0 70n 0 79n 0 80n 0 89n 0 90n 0 99n 0 100n 0 109n 0 ]
Vd7 (d7 0) vsource type=pwl wave=[ 0n 0 9n 0 10n 0 19n 0 20n 0 29n 0 30n 0 39n 0 40n 0 49n 0 50n 0 59n 0 60n 0 69n 0 70n 0 79n 0 80n 0 89n 0 90n 0 99n 0 100n 0 109n 0 ]
Vd6 (d6 0) vsource type=pwl wave=[ 0n 0 9n 0 10n 0 19n 0 20n 0 29n 0 30n 0 39n 0 40n 0 49n 0 50n 0 59n 0 60n 0 69n 0 70n 0 79n 0 80n 0.9 89n 0.9 90n 0.9 99n 0.9 100n 0.9 109n 0.9 ]
Vd5 (d5 0) vsource type=pwl wave=[ 0n 0 9n 0 10n 0 19n 0 20n 0 29n 0 30n 0 39n 0 40n 0 49n 0 50n 0 59n 0 60n 0 69n 0 70n 0 79n 0 80n 0 89n 0 90n 0 99n 0 100n 0.9 109n 0.9 ]
Vd4 (d4 0) vsource type=pwl wave=[ 0n 0 9n 0 10n 0 19n 0 20n 0 29n 0 30n 0 39n 0 40n 0 49n 0 50n 0 59n 0 60n 0.9 69n 0.9 70n 0.9 79n 0.9 80n 0 89n 0 90n 0.9 99n 0.9 100n 0.9 109n 0.9 ]
Vd3 (d3 0) vsource type=pwl wave=[ 0n 0 9n 0 10n 0 19n 0 20n 0 29n 0 30n 0 39n 0 40n 0 49n 0 50n 0.9 59n 0.9 60n 0 69n 0 70n 0.9 79n 0.9 80n 0 89n 0 90n 0.9 99n 0.9 100n 0.9 109n 0.9 ]
Vd2 (d2 0) vsource type=pwl wave=[ 0n 0 9n 0 10n 0 19n 0 20n 0 29n 0 30n 0 39n 0 40n 0.9 49n 0.9 50n 0 59n 0 60n 0 69n 0 70n 0.9 79n 0.9 80n 0 89n 0 90n 0 99n 0 100n 0.9 109n 0.9 ]
Vd1 (d1 0) vsource type=pwl wave=[ 0n 0 9n 0 10n 0 19n 0 20n 0.9 29n 0.9 30n 0.9 39n 0.9 40n 0 49n 0 50n 0.9 59n 0.9 60n 0 69n 0 70n 0.9 79n 0.9 80n 0 89n 0 90n 0.9 99n 0.9 100n 0.9 109n 0.9 ]
Vd0 (d0 0) vsource type=pwl wave=[ 0n 0 9n 0 10n 0.9 19n 0.9 20n 0 29n 0 30n 0.9 39n 0.9 40n 0.9 49n 0.9 50n 0 59n 0 60n 0.9 69n 0.9 70n 0.9 79n 0.9 80n 0 89n 0 90n 0.9 99n 0.9 100n 0.9 109n 0.9 ]

XDUT (en d127 d126 d125 d124 d123 d122 d121 d120 d119 d118 d117 d116 d115 d114 d113 d112 d111 d110 d109 d108 d107 d106 d105 d104 d103 d102 d101 d100 d99 d98 d97 d96 d95 d94 d93 d92 d91 d90 d89 d88 d87 d86 d85 d84 d83 d82 d81 d80 d79 d78 d77 d76 d75 d74 d73 d72 d71 d70 d69 d68 d67 d66 d65 d64 d63 d62 d61 d60 d59 d58 d57 d56 d55 d54 d53 d52 d51 d50 d49 d48 d47 d46 d45 d44 d43 d42 d41 d40 d39 d38 d37 d36 d35 d34 d33 d32 d31 d30 d29 d28 d27 d26 d25 d24 d23 d22 d21 d20 d19 d18 d17 d16 d15 d14 d13 d12 d11 d10 d9 d8 d7 d6 d5 d4 d3 d2 d1 d0 q127 q126 q125 q124 q123 q122 q121 q120 q119 q118 q117 q116 q115 q114 q113 q112 q111 q110 q109 q108 q107 q106 q105 q104 q103 q102 q101 q100 q99 q98 q97 q96 q95 q94 q93 q92 q91 q90 q89 q88 q87 q86 q85 q84 q83 q82 q81 q80 q79 q78 q77 q76 q75 q74 q73 q72 q71 q70 q69 q68 q67 q66 q65 q64 q63 q62 q61 q60 q59 q58 q57 q56 q55 q54 q53 q52 q51 q50 q49 q48 q47 q46 q45 q44 q43 q42 q41 q40 q39 q38 q37 q36 q35 q34 q33 q32 q31 q30 q29 q28 q27 q26 q25 q24 q23 q22 q21 q20 q19 q18 q17 q16 q15 q14 q13 q12 q11 q10 q9 q8 q7 q6 q5 q4 q3 q2 q1 q0) config_latch_128b

tran tran stop=110n maxstep=200p
save en d127 d126 d125 d124 d123 d122 d121 d120 d119 d118 d117 d116 d115 d114 d113 d112 d111 d110 d109 d108 d107 d106 d105 d104 d103 d102 d101 d100 d99 d98 d97 d96 d95 d94 d93 d92 d91 d90 d89 d88 d87 d86 d85 d84 d83 d82 d81 d80 d79 d78 d77 d76 d75 d74 d73 d72 d71 d70 d69 d68 d67 d66 d65 d64 d63 d62 d61 d60 d59 d58 d57 d56 d55 d54 d53 d52 d51 d50 d49 d48 d47 d46 d45 d44 d43 d42 d41 d40 d39 d38 d37 d36 d35 d34 d33 d32 d31 d30 d29 d28 d27 d26 d25 d24 d23 d22 d21 d20 d19 d18 d17 d16 d15 d14 d13 d12 d11 d10 d9 d8 d7 d6 d5 d4 d3 d2 d1 d0 q127 q126 q125 q124 q123 q122 q121 q120 q119 q118 q117 q116 q115 q114 q113 q112 q111 q110 q109 q108 q107 q106 q105 q104 q103 q102 q101 q100 q99 q98 q97 q96 q95 q94 q93 q92 q91 q90 q89 q88 q87 q86 q85 q84 q83 q82 q81 q80 q79 q78 q77 q76 q75 q74 q73 q72 q71 q70 q69 q68 q67 q66 q65 q64 q63 q62 q61 q60 q59 q58 q57 q56 q55 q54 q53 q52 q51 q50 q49 q48 q47 q46 q45 q44 q43 q42 q41 q40 q39 q38 q37 q36 q35 q34 q33 q32 q31 q30 q29 q28 q27 q26 q25 q24 q23 q22 q21 q20 q19 q18 q17 q16 q15 q14 q13 q12 q11 q10 q9 q8 q7 q6 q5 q4 q3 q2 q1 q0
