`include "constants.vams"
`include "disciplines.vams"

module config_latch_128b(
    input electrical en,
    input electrical [127:0] d,
    output electrical [127:0] q
);
    parameter real vdd = 0.9;
    parameter real vth = 0.45;
    parameter real tr = 20p;

    genvar i;

    analog begin
        for (i = 0; i < 128; i = i + 1) begin
            V(q[i]) <+ transition(((V(en) > vth) && (V(d[i]) > vth)) ? vdd : 0.0, 0, tr, tr);
        end
    end
endmodule
