simulator lang=spectre
global 0

ahdl_include "continuous_laplace_nd_filter.va"

Vin (inp 0) vsource type=pwl wave=[0 0.0 20n 0.0 21n 1.0 80n 1.0 81n 0.0 160n 0.0]

XDUT (inp out) continuous_laplace_nd_filter

tran tran stop=160n
save inp out
