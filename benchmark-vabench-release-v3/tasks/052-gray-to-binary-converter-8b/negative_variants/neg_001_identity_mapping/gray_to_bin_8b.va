`include "constants.vams"
`include "disciplines.vams"

module gray_to_bin_8b(
    input electrical [7:0] g,
    output electrical [7:0] b
);
    parameter real vdd = 0.9;
    parameter real vth = 0.45;
    parameter real tr = 20p;

    integer bit_y[7:0];
    integer running;
    integer bit_g;
    integer j;
    genvar i;

    analog begin
        for (j = 0; j < 8; j = j + 1) bit_y[j] = (V(g[j]) > vth) ? 1 : 0;
        for (i = 0; i < 8; i = i + 1) begin
            V(b[i]) <+ transition((bit_y[i]) ? vdd : 0.0, 0, tr, tr);
        end
    end
endmodule
