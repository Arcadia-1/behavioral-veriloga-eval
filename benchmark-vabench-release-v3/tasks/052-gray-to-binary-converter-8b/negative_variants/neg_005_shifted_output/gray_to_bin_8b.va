`include "constants.vams"
`include "disciplines.vams"

module gray_to_bin_8b(
    g7,
    g6,
    g5,
    g4,
    g3,
    g2,
    g1,
    g0,
    b7,
    b6,
    b5,
    b4,
    b3,
    b2,
    b1,
    b0
);
    input g7, g6, g5, g4, g3, g2, g1, g0;
    output b7, b6, b5, b4, b3, b2, b1, b0;
    electrical g7, g6, g5, g4, g3, g2, g1, g0, b7, b6, b5, b4, b3, b2, b1, b0;
    parameter real vdd = 0.9;
    parameter real vth = 0.45;
    parameter real tr = 20p;
    analog begin
        V(b0) <+ transition((V(g1) > vth) ? vdd : 0.0, 0, tr, tr);
        V(b1) <+ transition((V(g2) > vth) ? vdd : 0.0, 0, tr, tr);
        V(b2) <+ transition((V(g3) > vth) ? vdd : 0.0, 0, tr, tr);
        V(b3) <+ transition((V(g4) > vth) ? vdd : 0.0, 0, tr, tr);
        V(b4) <+ transition((V(g5) > vth) ? vdd : 0.0, 0, tr, tr);
        V(b5) <+ transition((V(g6) > vth) ? vdd : 0.0, 0, tr, tr);
        V(b6) <+ transition((V(g7) > vth) ? vdd : 0.0, 0, tr, tr);
        V(b7) <+ transition((V(g0) > vth) ? vdd : 0.0, 0, tr, tr);
    end
endmodule
