`include "constants.vams"
`include "disciplines.vams"

module gray_to_bin_8b(
    input electrical [7:0] g,
    output electrical [7:0] b
);
    parameter real vdd = 0.9;
    parameter real vth = 0.45;
    parameter real tr = 20p;
    genvar i;
    analog begin
        for (i = 0; i < 8; i = i + 1) V(b[i]) <+ transition(0.0, 0, tr, tr);
    end
endmodule
