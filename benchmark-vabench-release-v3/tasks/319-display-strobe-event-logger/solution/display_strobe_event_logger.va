`include "constants.vams"
`include "disciplines.vams"

module display_strobe_event_logger (
    input  electrical vin,
    input  electrical clk,
    input  electrical mode,
    input  electrical rst,
    output electrical out,
    output electrical metric
);
parameter real vth = 0.45;
parameter real vhi = 0.9;
parameter real tr = 200p;
real out_v;
real metric_v;
integer count_q;
integer state_q;
integer class_q;
analog begin
    @(initial_step) begin
        out_v = 0.0;
        metric_v = 0.0;
        count_q = 0;
        state_q = 0;
        class_q = 0;
        $display("display_strobe_event_logger init");
    end
    @(cross(V(clk) - vth, +1) or cross(V(rst) - vth, +1)) begin
        if (V(rst) > vth) begin
            count_q = 0;
            state_q = 0;
            class_q = 0;
            out_v = 0.0;
            metric_v = 0.0;
            $display("event_logger reset at %g", $abstime);
        end else begin
            count_q = count_q + 1;
            if (V(vin) < 0.30) begin
                class_q = 1;
                out_v = 0.225;
            end else if (V(vin) < 0.70) begin
                class_q = 2;
                out_v = 0.450;
            end else begin
                class_q = 3;
                out_v = 0.900;
            end
            state_q = class_q;
            metric_v = count_q / 4.0;
            if (metric_v > 1.0) metric_v = 1.0;
            $strobe("event_logger count=%0d class=%0d vin=%g", count_q, class_q, V(vin));
        end
    end
    V(out) <+ transition(out_v, 0.0, tr, tr);
    V(metric) <+ transition(metric_v, 0.0, tr, tr);
end
endmodule
