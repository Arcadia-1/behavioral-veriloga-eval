connectrules connectrules_electrical_map_rules;
    connect electrical electrical connectrules_electrical_map_bridge;
endconnectrules

connectmodule connectrules_electrical_map_bridge(input electrical a, output electrical y);
    analog begin
        V(y) <+ (V(rst) > 0.45 ? 0.25 : (V(a)));
    end
endconnectmodule

module connectrules_electrical_map();
endmodule
