simulator lang=spectre
global 0

ahdl_include "reference_settling_window_monitor.va"

Vclk (clk 0) vsource type=pulse val0=0 val1=0.9 delay=150p period=1n width=420p rise=20p fall=20p
Vrst (rst 0) vsource type=pwl wave=[0 0.9 1.2n 0.9 1.25n 0.0 11n 0.0 11.05n 0.9 12n 0.9 12.05n 0.0 20n 0.0]
Vtarget (target 0) vsource type=pwl wave=[0 0.50 6n 0.50 6.05n 0.62 14n 0.62 14.05n 0.48 20n 0.48]
Vref (ref 0) vsource type=pwl wave=[0 0.30 2n 0.30 2.05n 0.49 5n 0.49 5.05n 0.56 7n 0.56 7.05n 0.63 11n 0.63 11.05n 0.70 13n 0.70 13.05n 0.62 15n 0.62 15.05n 0.44 17n 0.44 17.05n 0.49 20n 0.49]

XDUT (clk rst ref target valid err_metric settle_mon) reference_settling_window_monitor

tran tran stop=20n maxstep=10p
save clk rst ref target valid err_metric settle_mon
