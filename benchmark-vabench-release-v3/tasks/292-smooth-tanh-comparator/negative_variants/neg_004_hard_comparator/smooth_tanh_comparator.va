`include "disciplines.vams"
module smooth_tanh_comparator(sigin, sigref, sigout);
input sigin, sigref; output sigout; electrical sigin, sigref, sigout; parameter real sigin_offset=0.05;
analog begin V(sigout)<+((V(sigin,sigref)-sigin_offset)>0.0 ? 1.0 : -1.0); end
endmodule
