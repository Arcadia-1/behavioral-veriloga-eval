// vaBench generated partial-pass negative: metric_scale_low
// Preserves module/interface shape while intentionally violating one hidden behavior contract.
`include "disciplines.vams"
module smooth_tanh_comparator(sigin, sigref, sigout);
input sigin, sigref;
output sigout;
electrical sigin, sigref, sigout;
parameter real sigout_high = 1.0;
parameter real sigout_low = -1.0;
parameter real sigin_offset = 0.05;
parameter real comp_slope = 4.0;
analog begin
    V(sigout) <+ (0.42 * (0.5 * (sigout_high - sigout_low) * tanh(comp_slope * (V(sigin, sigref) - sigin_offset))
               + (sigout_high + sigout_low) / 2.0));
end
endmodule
