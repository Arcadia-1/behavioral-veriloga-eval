simulator lang=spectre
global 0
ahdl_include "dac4bit_small_swing.va"
Vd0 (vd0 0) vsource type=pwl wave=[0 1 0.80n 1 0.85n 0 1.60n 0 1.65n 1 2.40n 1 2.45n 0 3.20n 0 3.25n 0 4.20n 0]
Vd1 (vd1 0) vsource type=pwl wave=[0 1 0.80n 1 0.85n 0 1.60n 0 1.65n 0 2.40n 0 2.45n 1 3.20n 1 3.25n 0 4.20n 0]
Vd2 (vd2 0) vsource type=pwl wave=[0 1 0.80n 1 0.85n 0 1.60n 0 1.65n 0 2.40n 0 2.45n 1 3.20n 1 3.25n 1 4.20n 1]
Vd3 (vd3 0) vsource type=pwl wave=[0 1 0.80n 1 0.85n 0 1.60n 0 1.65n 1 2.40n 1 2.45n 0 3.20n 0 3.25n 1 4.20n 1]
XDUT (vd3 vd2 vd1 vd0 vout) dac4bit_small_swing
tran tran stop=4.0n maxstep=5p
save vd3 vd2 vd1 vd0 vout
