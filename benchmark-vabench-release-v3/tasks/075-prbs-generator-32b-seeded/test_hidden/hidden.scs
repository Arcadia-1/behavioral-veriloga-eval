simulator lang=spectre
global 0
ahdl_include "prbs_generator_32b.va"
Vclk (clk 0) vsource type=pulse val0=0 val1=0.9 period=10n delay=1n rise=50p fall=50p width=5n
Vrst (rst 0) vsource type=pwl wave=[0 0.9 8n 0.9 8.1n 0 180n 0]
Vload_seed (load_seed 0) vsource type=pwl wave=[0 0 12n 0 12.1n 0.9 22n 0.9 22.1n 0 180n 0]
Vseed0 (seed0 0) vsource type=pwl wave=[0 0.9 9.5n 0.9 10n 0.9]
Vseed1 (seed1 0) vsource type=pwl wave=[0 0.9 9.5n 0.9 10n 0.9]
Vseed2 (seed2 0) vsource type=pwl wave=[0 0.9 9.5n 0.9 10n 0.9]
Vseed3 (seed3 0) vsource type=pwl wave=[0 0 9.5n 0 10n 0]
Vseed4 (seed4 0) vsource type=pwl wave=[0 0 9.5n 0 10n 0]
Vseed5 (seed5 0) vsource type=pwl wave=[0 0.9 9.5n 0.9 10n 0.9]
Vseed6 (seed6 0) vsource type=pwl wave=[0 0.9 9.5n 0.9 10n 0.9]
Vseed7 (seed7 0) vsource type=pwl wave=[0 0 9.5n 0 10n 0]
Vseed8 (seed8 0) vsource type=pwl wave=[0 0.9 9.5n 0.9 10n 0.9]
Vseed9 (seed9 0) vsource type=pwl wave=[0 0 9.5n 0 10n 0]
Vseed10 (seed10 0) vsource type=pwl wave=[0 0.9 9.5n 0.9 10n 0.9]
Vseed11 (seed11 0) vsource type=pwl wave=[0 0 9.5n 0 10n 0]
Vseed12 (seed12 0) vsource type=pwl wave=[0 0 9.5n 0 10n 0]
Vseed13 (seed13 0) vsource type=pwl wave=[0 0 9.5n 0 10n 0]
Vseed14 (seed14 0) vsource type=pwl wave=[0 0.9 9.5n 0.9 10n 0.9]
Vseed15 (seed15 0) vsource type=pwl wave=[0 0 9.5n 0 10n 0]
Vseed16 (seed16 0) vsource type=pwl wave=[0 0.9 9.5n 0.9 10n 0.9]
Vseed17 (seed17 0) vsource type=pwl wave=[0 0.9 9.5n 0.9 10n 0.9]
Vseed18 (seed18 0) vsource type=pwl wave=[0 0 9.5n 0 10n 0]
Vseed19 (seed19 0) vsource type=pwl wave=[0 0 9.5n 0 10n 0]
Vseed20 (seed20 0) vsource type=pwl wave=[0 0 9.5n 0 10n 0]
Vseed21 (seed21 0) vsource type=pwl wave=[0 0.9 9.5n 0.9 10n 0.9]
Vseed22 (seed22 0) vsource type=pwl wave=[0 0 9.5n 0 10n 0]
Vseed23 (seed23 0) vsource type=pwl wave=[0 0 9.5n 0 10n 0]
Vseed24 (seed24 0) vsource type=pwl wave=[0 0.9 9.5n 0.9 10n 0.9]
Vseed25 (seed25 0) vsource type=pwl wave=[0 0 9.5n 0 10n 0]
Vseed26 (seed26 0) vsource type=pwl wave=[0 0 9.5n 0 10n 0]
Vseed27 (seed27 0) vsource type=pwl wave=[0 0 9.5n 0 10n 0]
Vseed28 (seed28 0) vsource type=pwl wave=[0 0 9.5n 0 10n 0]
Vseed29 (seed29 0) vsource type=pwl wave=[0 0 9.5n 0 10n 0]
Vseed30 (seed30 0) vsource type=pwl wave=[0 0 9.5n 0 10n 0]
Vseed31 (seed31 0) vsource type=pwl wave=[0 0 9.5n 0 10n 0]
XDUT (clk rst load_seed seed0 seed1 seed2 seed3 seed4 seed5 seed6 seed7 seed8 seed9 seed10 seed11 seed12 seed13 seed14 seed15 seed16 seed17 seed18 seed19 seed20 seed21 seed22 seed23 seed24 seed25 seed26 seed27 seed28 seed29 seed30 seed31 out0 out1 out2 out3 out4 out5 out6 out7 out8 out9 out10 out11 out12 out13 out14 out15 out16 out17 out18 out19 out20 out21 out22 out23 out24 out25 out26 out27 out28 out29 out30 out31) prbs_generator_32b
tran tran stop=180n maxstep=100p
save clk rst load_seed seed0 seed1 seed2 seed3 seed4 seed5 seed6 seed7 seed8 seed9 seed10 seed11 seed12 seed13 seed14 seed15 seed16 seed17 seed18 seed19 seed20 seed21 seed22 seed23 seed24 seed25 seed26 seed27 seed28 seed29 seed30 seed31 out0 out1 out2 out3 out4 out5 out6 out7 out8 out9 out10 out11 out12 out13 out14 out15 out16 out17 out18 out19 out20 out21 out22 out23 out24 out25 out26 out27 out28 out29 out30 out31
