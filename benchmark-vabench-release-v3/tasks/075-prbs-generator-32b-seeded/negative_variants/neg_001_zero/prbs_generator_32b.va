`include "constants.vams"
`include "disciplines.vams"

module prbs_generator_32b(clk, rst, load_seed, seed0, seed1, seed2, seed3, seed4, seed5, seed6, seed7, seed8, seed9, seed10, seed11, seed12, seed13, seed14, seed15, seed16, seed17, seed18, seed19, seed20, seed21, seed22, seed23, seed24, seed25, seed26, seed27, seed28, seed29, seed30, seed31, out0, out1, out2, out3, out4, out5, out6, out7, out8, out9, out10, out11, out12, out13, out14, out15, out16, out17, out18, out19, out20, out21, out22, out23, out24, out25, out26, out27, out28, out29, out30, out31);
    input clk, rst, load_seed, seed0, seed1, seed2, seed3, seed4, seed5, seed6, seed7, seed8, seed9, seed10, seed11, seed12, seed13, seed14, seed15, seed16, seed17, seed18, seed19, seed20, seed21, seed22, seed23, seed24, seed25, seed26, seed27, seed28, seed29, seed30, seed31;
    output out0, out1, out2, out3, out4, out5, out6, out7, out8, out9, out10, out11, out12, out13, out14, out15, out16, out17, out18, out19, out20, out21, out22, out23, out24, out25, out26, out27, out28, out29, out30, out31;
    electrical clk, rst, load_seed, seed0, seed1, seed2, seed3, seed4, seed5, seed6, seed7, seed8, seed9, seed10, seed11, seed12, seed13, seed14, seed15, seed16, seed17, seed18, seed19, seed20, seed21, seed22, seed23, seed24, seed25, seed26, seed27, seed28, seed29, seed30, seed31, out0, out1, out2, out3, out4, out5, out6, out7, out8, out9, out10, out11, out12, out13, out14, out15, out16, out17, out18, out19, out20, out21, out22, out23, out24, out25, out26, out27, out28, out29, out30, out31;

    parameter real vdd = 0.9;
    parameter real vth = 0.45;
    parameter real tr = 20p;

    analog begin
        V(out0) <+ transition(0.0, 0, tr, tr);
        V(out1) <+ transition(0.0, 0, tr, tr);
        V(out2) <+ transition(0.0, 0, tr, tr);
        V(out3) <+ transition(0.0, 0, tr, tr);
        V(out4) <+ transition(0.0, 0, tr, tr);
        V(out5) <+ transition(0.0, 0, tr, tr);
        V(out6) <+ transition(0.0, 0, tr, tr);
        V(out7) <+ transition(0.0, 0, tr, tr);
        V(out8) <+ transition(0.0, 0, tr, tr);
        V(out9) <+ transition(0.0, 0, tr, tr);
        V(out10) <+ transition(0.0, 0, tr, tr);
        V(out11) <+ transition(0.0, 0, tr, tr);
        V(out12) <+ transition(0.0, 0, tr, tr);
        V(out13) <+ transition(0.0, 0, tr, tr);
        V(out14) <+ transition(0.0, 0, tr, tr);
        V(out15) <+ transition(0.0, 0, tr, tr);
        V(out16) <+ transition(0.0, 0, tr, tr);
        V(out17) <+ transition(0.0, 0, tr, tr);
        V(out18) <+ transition(0.0, 0, tr, tr);
        V(out19) <+ transition(0.0, 0, tr, tr);
        V(out20) <+ transition(0.0, 0, tr, tr);
        V(out21) <+ transition(0.0, 0, tr, tr);
        V(out22) <+ transition(0.0, 0, tr, tr);
        V(out23) <+ transition(0.0, 0, tr, tr);
        V(out24) <+ transition(0.0, 0, tr, tr);
        V(out25) <+ transition(0.0, 0, tr, tr);
        V(out26) <+ transition(0.0, 0, tr, tr);
        V(out27) <+ transition(0.0, 0, tr, tr);
        V(out28) <+ transition(0.0, 0, tr, tr);
        V(out29) <+ transition(0.0, 0, tr, tr);
        V(out30) <+ transition(0.0, 0, tr, tr);
        V(out31) <+ transition(0.0, 0, tr, tr);
    end
endmodule
