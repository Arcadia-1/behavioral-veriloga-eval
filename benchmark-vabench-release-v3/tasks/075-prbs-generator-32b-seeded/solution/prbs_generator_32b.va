`include "constants.vams"
`include "disciplines.vams"

module prbs_generator_32b(
    input electrical clk,
    input electrical rst,
    input electrical load_seed,
    input electrical [0:31] seed,
    output electrical [0:31] out
);
    parameter real vdd = 0.9;
    parameter real vth = 0.45;
    parameter real tr = 20p;

    integer state[0:31];
    integer feedback;
    integer any_seed;
    integer i;
    genvar bit;

    analog begin
        @(initial_step) begin
            state[0] = 1;
            for (i = 1; i < 32; i = i + 1) begin
                state[i] = 0;
            end
        end

        @(cross(V(clk) - vth, +1)) begin
            if (V(rst) > vth) begin
                state[0] = 1;
                for (i = 1; i < 32; i = i + 1) begin
                    state[i] = 0;
                end
            end else if (V(load_seed) > vth) begin
                any_seed = 0;
                for (i = 0; i < 32; i = i + 1) begin
                    state[i] = (V(seed[i]) > vth) ? 1 : 0;
                    any_seed = any_seed | state[i];
                end
                if (!any_seed) state[0] = 1;
            end else begin
                feedback = (state[31] ^ state[21] ^ state[1] ^ state[0]) & 1;
                for (i = 31; i > 0; i = i - 1) begin
                    state[i] = state[i - 1];
                end
                state[0] = feedback;
            end
        end

        for (bit = 0; bit < 32; bit = bit + 1) begin
            V(out[bit]) <+ transition(state[bit] ? vdd : 0.0, 0, tr, tr);
        end
    end
endmodule
