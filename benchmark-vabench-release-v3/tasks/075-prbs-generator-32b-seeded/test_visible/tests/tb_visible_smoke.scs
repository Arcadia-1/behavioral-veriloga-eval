simulator lang=spectre
global 0

ahdl_include "prbs_generator_32b.va"

V_clk (clk 0) vsource type=pulse val0=0 val1=0.9 period=1n delay=100p rise=20p fall=20p width=450p
V_rst (rst 0) vsource type=pulse val0=0.9 val1=0 period=20n delay=1n rise=50p fall=50p width=18n
V_load_seed (load_seed 0) vsource type=pulse val0=0 val1=0.9 period=4n delay=600p rise=50p fall=50p width=1.5n
V_seed0 (seed0 0) vsource dc=0.9
V_seed1 (seed1 0) vsource dc=0.0
V_seed2 (seed2 0) vsource dc=0.9
V_seed3 (seed3 0) vsource dc=0.0
V_seed4 (seed4 0) vsource dc=0.9
V_seed5 (seed5 0) vsource dc=0.0
V_seed6 (seed6 0) vsource dc=0.9
V_seed7 (seed7 0) vsource dc=0.0
V_seed8 (seed8 0) vsource dc=0.9
V_seed9 (seed9 0) vsource dc=0.0
V_seed10 (seed10 0) vsource dc=0.9
V_seed11 (seed11 0) vsource dc=0.0
V_seed12 (seed12 0) vsource dc=0.9
V_seed13 (seed13 0) vsource dc=0.0
V_seed14 (seed14 0) vsource dc=0.9
V_seed15 (seed15 0) vsource dc=0.0
V_seed16 (seed16 0) vsource dc=0.9
V_seed17 (seed17 0) vsource dc=0.0
V_seed18 (seed18 0) vsource dc=0.9
V_seed19 (seed19 0) vsource dc=0.0
V_seed20 (seed20 0) vsource dc=0.9
V_seed21 (seed21 0) vsource dc=0.0
V_seed22 (seed22 0) vsource dc=0.9
V_seed23 (seed23 0) vsource dc=0.0
V_seed24 (seed24 0) vsource dc=0.9
V_seed25 (seed25 0) vsource dc=0.0
V_seed26 (seed26 0) vsource dc=0.9
V_seed27 (seed27 0) vsource dc=0.0
V_seed28 (seed28 0) vsource dc=0.9
V_seed29 (seed29 0) vsource dc=0.0
V_seed30 (seed30 0) vsource dc=0.9
V_seed31 (seed31 0) vsource dc=0.0

XDUT (clk rst load_seed seed0 seed1 seed2 seed3 seed4 seed5 seed6 seed7 seed8 seed9 seed10 seed11 seed12 seed13 seed14 seed15 seed16 seed17 seed18 seed19 seed20 seed21 seed22 seed23 seed24 seed25 seed26 seed27 seed28 seed29 seed30 seed31 out0 out1 out2 out3 out4 out5 out6 out7 out8 out9 out10 out11 out12 out13 out14 out15 out16 out17 out18 out19 out20 out21 out22 out23 out24 out25 out26 out27 out28 out29 out30 out31) prbs_generator_32b

tran tran stop=8n maxstep=100p
save clk rst load_seed seed0 seed1 seed2 seed3 seed4 seed5 seed6 seed7 seed8 seed9 seed10 seed11 seed12 seed13 seed14 seed15 seed16 seed17 seed18 seed19 seed20 seed21 seed22 seed23 seed24 seed25 seed26 seed27 seed28 seed29 seed30 seed31 out0 out1 out2 out3 out4 out5 out6 out7 out8 out9 out10 out11 out12 out13 out14 out15 out16 out17 out18 out19 out20 out21 out22 out23 out24 out25 out26 out27 out28 out29 out30 out31
