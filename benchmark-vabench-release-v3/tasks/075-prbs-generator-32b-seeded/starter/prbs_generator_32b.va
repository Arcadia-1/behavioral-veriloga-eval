`include "constants.vams"
`include "disciplines.vams"

module prbs_generator_32b(
    input electrical clk,
    input electrical rst,
    input electrical load_seed,
    input electrical [0:31] seed,
    output electrical [0:31] out
);
    parameter real vdd = 0.9;
    parameter real vth = 0.45;
    parameter real tr = 20p;

    genvar bit;

    analog begin
        for (bit = 0; bit < 32; bit = bit + 1) begin
            V(out[bit]) <+ transition(0.0, 0, tr, tr);
        end
    end
endmodule
