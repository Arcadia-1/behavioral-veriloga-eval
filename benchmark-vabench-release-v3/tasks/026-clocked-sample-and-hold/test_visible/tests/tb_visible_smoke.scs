simulator lang=spectre
global 0

ahdl_include "sample_hold.va"

V_VDD (vdd 0) vsource dc=0.9
V_VSS (vss 0) vsource dc=0
V_IN (in 0) vsource type=pwl wave=[0 0 240n 0.9]
V_CLK (clk 0) vsource type=pulse val0=0 val1=0.9 period=20n delay=1n rise=200p fall=200p width=10n

XDUT (vdd vss in clk out) sample_hold

tran tran stop=240n maxstep=1n
save in clk out
