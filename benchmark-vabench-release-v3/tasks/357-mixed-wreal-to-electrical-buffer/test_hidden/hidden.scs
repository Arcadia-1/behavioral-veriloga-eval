simulator lang=spectre
global 0

ahdl_include "mixed_wreal_to_electrical_buffer.vams"

Vvin (vin 0) vsource dc=0.65
Vclk (clk 0) vsource dc=0.0
Ven (en 0) vsource dc=1.0
Vsel (sel 0) vsource dc=0.0
Va (a 0) vsource type=pwl wave=[0 0.30 169n 0.30 170n 0.72 389n 0.72 390n 0.18 579n 0.18 580n 0.62 760n 0.62]
Vb (b 0) vsource dc=0.1

XDUT (vin clk en sel a b vout) mixed_wreal_to_electrical_buffer

tran tran stop=760n
save vin clk en sel a b vout
