`include "constants.vams"
`include "disciplines.vams"

module successive_approximation_calibration_search_fsm(clk, rst, vin, out, metric);
input clk, rst, vin;
output out, metric;
electrical clk, rst, vin, out, metric;
parameter real tr = 100p;
parameter real vth = 0.45;
parameter real target = 0.45;
parameter real step_init = 0.18;
parameter real vmin = 0.05;
parameter real vmax = 0.85;

    // TODO: implement the behavior described in visible/prompt.md.
    // This starter is intentionally incomplete; implement the public behavior contract.
endmodule
