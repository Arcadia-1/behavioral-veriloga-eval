simulator lang=spectre
global 0

ahdl_include "cmp_offset_ref.va"

Vvdd (VDD 0) vsource dc=0.9
Vvss (VSS 0) vsource dc=0
Vclk (CLK 0) vsource type=pulse val0=0 val1=0.9 delay=1n rise=20p fall=20p width=1n period=4n

// Public smoke staircase:
// 1n: -10mV -> low, 5n: +3mV -> low, 9n: +7mV -> high.
// The +7mV step occurs after the 5n edge, so OUT_P must not change until 9n.
Vinp (VINP 0) vsource type=pwl wave=[ \
    0      0.440 \
    4.2n   0.453 \
    8.2n   0.457 \
    12n    0.457 \
]
Vinn (VINN 0) vsource dc=0.450

XDUT (VDD VSS CLK VINP VINN OUT_P) cmp_offset_ref

tran tran stop=12n maxstep=20p
save CLK VINP VINN OUT_P
