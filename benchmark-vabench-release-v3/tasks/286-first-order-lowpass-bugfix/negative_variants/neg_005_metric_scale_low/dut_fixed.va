// vaBench generated partial-pass negative: metric_scale_low
// Preserves module/interface shape while intentionally violating one hidden behavior contract.
`include "constants.vams"
`include "disciplines.vams"
module first_order_lowpass(vin,vout);
    input vin; output vout; electrical vin,vout; parameter real alpha=0.025; parameter real tr=200p; real y;
    analog begin @(initial_step) y=0.0; @(timer(0,500p)) y = y + alpha*(V(vin)-y); V(vout)<+(0.42 * (transition(y,0,tr,tr))); end
endmodule
