`include "disciplines.vams"

module offset_bisection_driver(clk, vout, vcm, vinp, vinn);
input clk, vout, vcm;
output vinp, vinn;
electrical clk, vout, vcm, vinp, vinn;

analog begin
    V(vinp) <+ V(vcm);
    V(vinn) <+ V(vcm);
end

endmodule
