`include "constants.vams"
`include "disciplines.vams"

module string_config_label_select (
    input  electrical vin,
    input  electrical clk,
    input  electrical mode,
    input  electrical rst,
    output electrical out,
    output electrical metric
);
parameter real vth = 0.45;
parameter real vhi = 0.9;
parameter real tr = 200p;
real out_v;
real metric_v;
integer count_q;
string label_q;
integer fd;
analog begin
    @(initial_step) begin
        out_v = 0.0;
        metric_v = 0.0;
        count_q = 0;
    end
    @(cross(V(clk) - vth, +1)) begin
        if (V(rst) > vth) begin
            out_v = 0.0;
            metric_v = 0.0;
            count_q = 0;
        end else begin
            if (V(mode) > vth) begin
                out_v = V(vin) > vth ? 0.0 : vhi;
                metric_v = count_q + 10;
                label_q = $sformat("cfg=B count=%0d vin=%0.3f", count_q, V(vin));
            end else begin
                out_v = V(vin) > vth ? vhi : 0.0;
                metric_v = count_q;
                label_q = $sformat("cfg=A count=%0d vin=%0.3f", count_q, V(vin));
            end
            count_q = count_q + 1;
        end
    end
    V(out) <+ transition(out_v, 0.0, tr, tr);
    V(metric) <+ transition(metric_v, 0.0, tr, tr);
end
endmodule
