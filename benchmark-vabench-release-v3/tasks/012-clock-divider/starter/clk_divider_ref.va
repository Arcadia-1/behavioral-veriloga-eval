`include "constants.vams"
`include "disciplines.vams"

module clk_divider_ref (
    input electrical clk_in,
    input electrical rst_n,
    input electrical div_code_0,
    input electrical div_code_1,
    input electrical div_code_2,
    input electrical div_code_3,
    input electrical div_code_4,
    input electrical div_code_5,
    input electrical div_code_6,
    input electrical div_code_7,
    output electrical clk_out,
    output electrical lock
);

parameter real vdd = 0.9;
parameter real vth = 0.45;
parameter real trf = 10p;
parameter real td  = 0p;

analog begin
    // TODO: implement the resettable programmable divider described in
    // instruction.md. The evaluator grades clk_out and lock from voltage
    // waveforms generated by this module.
    V(clk_out) <+ transition(0.0, td, trf, trf);
    V(lock)    <+ transition(0.0, td, trf, trf);
end

endmodule
