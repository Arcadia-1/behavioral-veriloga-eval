simulator lang=spectre
global 0

ahdl_include "clk_divider_ref.va"

Vclk  (clk_in 0) vsource type=pulse val0=0 val1=0.9 period=1n delay=100p rise=20p fall=20p width=500p
Vrst  (rst_n  0) vsource type=pulse val0=0 val1=0.9 period=40n delay=1n rise=20p fall=20p width=39n

// Public smoke ratio = 3 (00000011). Hidden scoring may use different
// deterministic stimulus; the required behavior is specified in instruction.md.
Vb0 (div_code_0 0) vsource dc=0.9
Vb1 (div_code_1 0) vsource dc=0.9
Vb2 (div_code_2 0) vsource dc=0.0
Vb3 (div_code_3 0) vsource dc=0.0
Vb4 (div_code_4 0) vsource dc=0.0
Vb5 (div_code_5 0) vsource dc=0.0
Vb6 (div_code_6 0) vsource dc=0.0
Vb7 (div_code_7 0) vsource dc=0.0

XDUT (clk_in rst_n div_code_0 div_code_1 div_code_2 div_code_3 div_code_4 div_code_5 div_code_6 div_code_7 clk_out lock) clk_divider_ref

tran tran stop=20n maxstep=50p
save clk_in rst_n clk_out lock \
	div_code_0 div_code_1 div_code_2 div_code_3 \
	div_code_4 div_code_5 div_code_6 div_code_7
