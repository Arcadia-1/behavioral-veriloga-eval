`include "disciplines.vams"

module first_order_sigma_delta_modulator(vin, vclk, bitout);
input vin, vclk;
output bitout;
electrical vin, vclk, bitout;

analog begin
    V(bitout) <+ 0.0;
end
endmodule
