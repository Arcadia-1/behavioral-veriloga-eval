simulator lang=spectre
global 0

ahdl_include "clocked_dac_restore_4b.va"

Vclk (clk 0) vsource type=pulse val0=0 val1=0.9 delay=5n period=10n width=4n rise=100p fall=100p
Vd3 (d3 0) vsource type=pwl wave=[0 0 14n 0 14.2n 0 24n 0.9 24.2n 0.9 34n 0.9 34.2n 0.9 60n 0.9]
Vd2 (d2 0) vsource type=pwl wave=[0 0 14n 0.9 14.2n 0.9 24n 0 24.2n 0 34n 0.9 34.2n 0.9 60n 0.9]
Vd1 (d1 0) vsource type=pwl wave=[0 0 14n 0 14.2n 0 24n 0.9 24.2n 0.9 34n 0.9 34.2n 0.9 60n 0.9]
Vd0 (d0 0) vsource type=pwl wave=[0 0 14n 0.9 14.2n 0.9 24n 0 24.2n 0 34n 0.9 34.2n 0.9 60n 0.9]

XDUT (d3 d2 d1 d0 clk vout) clocked_dac_restore_4b

tran tran stop=50n maxstep=50p
save d3 d2 d1 d0 clk vout
