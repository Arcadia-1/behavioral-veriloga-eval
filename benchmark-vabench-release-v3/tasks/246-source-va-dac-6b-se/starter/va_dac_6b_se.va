`include "disciplines.vams"
module va_dac_6b_se(din0, din1, din2, din3, din4, din5, rdy, aout);
input din0, din1, din2, din3, din4, din5, rdy;
output aout;
electrical din0, din1, din2, din3, din4, din5, rdy, aout;
analog begin
    V(aout) <+ 0.0;
end
endmodule
