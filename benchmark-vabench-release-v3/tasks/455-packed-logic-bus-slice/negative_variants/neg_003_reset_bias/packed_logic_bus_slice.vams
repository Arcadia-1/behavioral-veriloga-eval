module packed_logic_bus_slice(input [7:0] a, output [3:0] y);
    logic [7:0] a;
    logic [3:0] y;
    assign y = (V(rst) > 0.45 ? 0.25 : ({a[7:6], a[1:0]}));
endmodule
