simulator lang=spectre
global 0
// Hidden behavior skeleton. Evaluator supplies the candidate Verilog-A/AMS artifact and stricter checks.
tran tran stop=160n
save vin clk mode rst out metric
