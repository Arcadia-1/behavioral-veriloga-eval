`include "constants.vams"
`include "disciplines.vams"

module hierarchy_nested_parameter_chain (
    input  electrical vin,
    input  electrical clk,
    input  electrical mode,
    input  electrical rst,
    output electrical out,
    output electrical metric
);
analog begin
    V(out) <+ 0.0;
    V(metric) <+ 0.0;
end
endmodule
