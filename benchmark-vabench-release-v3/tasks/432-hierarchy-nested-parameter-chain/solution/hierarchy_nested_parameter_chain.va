`include "constants.vams"
`include "disciplines.vams"

module hierarchy_nested_parameter_chain (
    input  electrical vin,
    input  electrical clk,
    input  electrical mode,
    input  electrical rst,
    output electrical out,
    output electrical metric
);
parameter real tr = 200p;
electrical mid;
    staged_gain_child #(.gain(1.2)) u_gain0(.vin(vin), .out(mid));
    staged_gain_child #(.gain(0.5)) u_gain1(.vin(mid), .out(out));
analog begin
    V(metric) <+ transition(V(mid), 0.0, tr, tr);
end
endmodule
