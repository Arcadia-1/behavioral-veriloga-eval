`include "constants.vams"
`include "disciplines.vams"

module task_output_limiter (
    input  electrical vin,
    input  electrical clk,
    input  electrical mode,
    input  electrical rst,
    output electrical out,
    output electrical metric
);
parameter real vth = 0.45;
parameter real vhi = 0.9;
parameter real tr = 200p;
task update_outputs;
    input real sample;
    input integer mode_code;
    begin
        if (mode_code == 0) out_v = sample;
        else if (mode_code == 1) out_v = sample > vth ? vhi : 0.0;
        else out_v = sample < 0.0 ? 0.0 : (sample > vhi ? vhi : sample);
        metric_v = out_v / vhi;
    end
endtask
real out_v;
real metric_v;
integer count_q;
integer state_q;
analog begin
    @(initial_step) begin
        out_v = 0.0;
        metric_v = 0.0;
        count_q = 0;
        state_q = 0;
    end
    @(cross(V(clk) - vth, +1)) begin
        if (V(rst) > vth) begin
            out_v = 0.0;
            metric_v = 0.0;
            count_q = 0;
            state_q = 0;
        end else begin
            count_q = count_q + 1;
            state_q = count_q % 3;
            update_outputs(V(vin), state_q);
        end
    end
    V(out) <+ transition(out_v, 0.0, tr, tr);
    V(metric) <+ transition(metric_v, 0.0, tr, tr);
end
endmodule
