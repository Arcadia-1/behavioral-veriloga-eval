`include "constants.vams"
`include "disciplines.vams"

module task_output_limiter (
    input  electrical vin,
    input  electrical clk,
    input  electrical mode,
    input  electrical rst,
    output electrical out,
    output electrical metric
);
parameter real vth = 0.45;
parameter real vhi = 0.9;
parameter real tr = 200p;
real out_v;
real metric_v;
integer count_q;
integer state_q;

task update_outputs;
    input real sample;
    input integer mode_code;
    begin
        // TODO: update out_v and metric_v according to mode_code.
    end
endtask

analog begin
    @(initial_step) begin
        out_v = 0.0;
        metric_v = 0.0;
        count_q = 0;
        state_q = 0;
    end
    // TODO: call update_outputs from the clk crossing event.
    V(out) <+ transition(out_v, 0.0, tr, tr);
    V(metric) <+ transition(metric_v, 0.0, tr, tr);
end
endmodule
