simulator lang=spectre
global 0

ahdl_include "slew_rate_limiter.va"

V_vin (vin 0) vsource type=pulse val0=0 val1=0.9 period=3n delay=0p rise=50p fall=50p width=1.4n

XDUT (vin vout) slew_rate_limiter

tran tran stop=5n maxstep=100p
save vin vout
