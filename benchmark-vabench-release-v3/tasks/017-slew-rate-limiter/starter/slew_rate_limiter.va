`include "constants.vams"
`include "disciplines.vams"
module slew_rate_limiter(vin,vout);
    input vin; output vout; electrical vin,vout; parameter real step=0.015; parameter real tr=200p; real y;

    // TODO: implement the behavior described in instruction.md.
    // This starter is intentionally incomplete; implement the required behavior.
endmodule
