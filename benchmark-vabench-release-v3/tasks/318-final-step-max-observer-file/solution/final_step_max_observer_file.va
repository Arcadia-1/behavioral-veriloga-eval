`include "constants.vams"
`include "disciplines.vams"

module final_step_max_observer_file (
    input  electrical vin,
    input  electrical clk,
    input  electrical mode,
    input  electrical rst,
    output electrical out,
    output electrical metric
);
parameter real vth = 0.45;
parameter real vhi = 0.9;
parameter real tr = 200p;
real out_v;
real metric_v;
integer count_q;
integer state_q;
integer fd;
real max_q;
analog begin
    @(initial_step) begin
        out_v = 0.0;
        metric_v = 0.0;
        count_q = 0;
        state_q = 0;
        max_q = 0.0;
    end
    @(cross(V(clk) - vth, +1) or cross(V(rst) - vth, +1)) begin
        if (V(rst) > vth) begin
            count_q = 0;
            state_q = 0;
            max_q = 0.0;
            out_v = 0.0;
            metric_v = 0.0;
        end else begin
            count_q = count_q + 1;
            state_q = count_q;
            if (V(vin) > max_q) max_q = V(vin);
            out_v = max_q;
            metric_v = max_q / vhi;
            if (metric_v > 1.0) metric_v = 1.0;
            if (metric_v < 0.0) metric_v = 0.0;
            $strobe("sample_max count=%0d max=%g metric=%g", count_q, max_q, metric_v);
        end
    end
    @(final_step) begin
        fd = $fopen("candidate.out", "w");
        $fwrite(fd, "count=%0d max=%.3f metric=%.3f", count_q, max_q, metric_v);
        $fclose(fd);
    end
    V(out) <+ transition(out_v, 0.0, tr, tr);
    V(metric) <+ transition(metric_v, 0.0, tr, tr);
end
endmodule
