`include "disciplines.vams"

module dac_8bit_ideal_scalar(vd7, vd6, vd5, vd4, vd3, vd2, vd1, vd0, vout);
input vd7, vd6, vd5, vd4, vd3, vd2, vd1, vd0;
output vout;
electrical vd7, vd6, vd5, vd4, vd3, vd2, vd1, vd0, vout;

analog begin
    V(vout) <+ 0;
end

endmodule
