`include "disciplines.vams"

module dac_8bit_ideal_scalar(vd7, vd6, vd5, vd4, vd3, vd2, vd1, vd0, vout);
input vd7, vd6, vd5, vd4, vd3, vd2, vd1, vd0;
output vout;
electrical vd7, vd6, vd5, vd4, vd3, vd2, vd1, vd0, vout;

parameter real vref = 1 from [0:inf];
parameter real trise = 1p from [0:inf];
parameter real tfall = 1p from [0:inf];
parameter real tdel = 0 from [0:inf];
parameter real vtrans = 2.5;
real code;
real out_value;

analog begin
    @(initial_step or cross(V(vd7) - vtrans, 0) or cross(V(vd6) - vtrans, 0) or
      cross(V(vd5) - vtrans, 0) or cross(V(vd4) - vtrans, 0) or
      cross(V(vd3) - vtrans, 0) or cross(V(vd2) - vtrans, 0) or
      cross(V(vd1) - vtrans, 0) or cross(V(vd0) - vtrans, 0)) begin
        code = 0;
        code = code + ((V(vd7) > vtrans) ? 128 : 0);
        code = code + ((V(vd6) > vtrans) ? 64 : 0);
        code = code + ((V(vd5) > vtrans) ? 32 : 0);
        code = code + ((V(vd4) > vtrans) ? 16 : 0);
        code = code + ((V(vd3) > vtrans) ? 8 : 0);
        code = code + ((V(vd2) > vtrans) ? 4 : 0);
        code = code + ((V(vd1) > vtrans) ? 2 : 0);
        code = code + ((V(vd0) > vtrans) ? 1 : 0);
        out_value = vref * code / 256.0;
    end

    V(vout) <+ transition(out_value, tdel, trise, tfall);
end

endmodule
