`include "constants.vams"
`include "disciplines.vams"

module dac_mismatch_unit_weighting_model(b0, b1, b2, b3, out);
input b0, b1, b2, b3;
output out;
electrical b0, b1, b2, b3, out;
parameter real vhi = 0.9;
parameter real vlo = 0.0;
parameter real tr = 100p;

    // TODO: implement the behavior described in instruction.md.
    // This starter is intentionally incomplete; implement the public behavior contract.
endmodule
