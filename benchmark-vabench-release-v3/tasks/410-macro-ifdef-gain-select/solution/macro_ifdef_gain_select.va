`include "constants.vams"
`include "disciplines.vams"
`define V3_HIGH_GAIN

module macro_ifdef_gain_select (
    input  electrical vin,
    input  electrical clk,
    input  electrical mode,
    input  electrical rst,
    output electrical out,
    output electrical metric
);
parameter real vth = 0.45;
parameter real vhi = 0.9;
parameter real tr = 200p;
`ifdef V3_HIGH_GAIN
parameter real selected_gain = 1.25;
`else
parameter real selected_gain = 0.75;
`endif
real out_v;
real metric_v;
integer count_q;
integer state_q;
analog begin
    @(initial_step) begin
        out_v = 0.0;
        metric_v = 0.0;
        count_q = 0;
        state_q = 0;
    end
    @(cross(V(clk) - vth, +1)) begin
        if (V(rst) > vth) begin
            out_v = 0.0;
            metric_v = 0.0;
            count_q = 0;
            state_q = 0;
        end else begin
        out_v = selected_gain * V(vin);
        metric_v = selected_gain;
        count_q = count_q + 1;
        end
    end
    V(out) <+ transition(out_v, 0.0, tr, tr);
    V(metric) <+ transition(metric_v, 0.0, tr, tr);
end
endmodule
