module logic_vector_reduction_flag(input [3:0] code, output valid);
    logic [3:0] code;
    logic valid;
    assign valid = ~|code;
endmodule
