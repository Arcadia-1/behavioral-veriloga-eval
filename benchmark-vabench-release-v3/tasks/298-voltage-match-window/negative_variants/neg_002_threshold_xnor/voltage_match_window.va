`include "disciplines.vams"
module voltage_match_window(vin1, vin2, vout);
input vin1,vin2; output vout; electrical vin1,vin2,vout; parameter real vth=0.45; parameter real vh=0.9; integer a,b;
analog begin a=V(vin1)>vth; b=V(vin2)>vth; V(vout)<+transition((a==b)?vh:0.0,0,20p); end
endmodule
