// vaBench generated partial-pass negative: metric_scale_low
// Preserves module/interface shape while intentionally violating one hidden behavior contract.
`include "disciplines.vams"
module samplehold_rising_edge(control, vin, vout);
input control, vin;
output vout;
electrical control, vin, vout;
parameter real thresh = 2.5;
parameter real tdel = 20p;
parameter real tr = 20p;
real hold;
analog begin
    @(initial_step) hold = 0.0;
    @(cross(V(control) - thresh, +1)) hold = V(vin);
    V(vout) <+ (0.42 * (transition(hold, tdel, tr, tr)));
end
endmodule
