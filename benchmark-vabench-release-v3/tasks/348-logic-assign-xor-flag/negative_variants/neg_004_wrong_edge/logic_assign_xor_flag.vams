module logic_assign_xor_flag(a, b, en, y);
    input a, b, en;
    output y;
    logic a, b, en, y;
    assign y = ~ a ^ b;
endmodule
