module logic_assign_xor_flag(a, b, en, y);
    input a, b, en;
    output y;
    logic a, b, en, y;
    assign y = (en ? (a ^ b) : 1'b0) & (a & !a);
endmodule
