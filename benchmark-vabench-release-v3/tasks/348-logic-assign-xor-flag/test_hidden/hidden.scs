simulator lang=spectre
global 0

ahdl_include "logic_assign_xor_flag.vams"

Va (a 0) vsource type=pwl wave=[0 0.0 159n 0.0 160n 1.0 319n 1.0 320n 0.0 489n 0.0 490n 1.0 650n 1.0]
Vb (b 0) vsource type=pwl wave=[0 1.0 239n 1.0 240n 0.0 399n 0.0 400n 1.0 650n 1.0]
Ven (en 0) vsource type=pwl wave=[0 1.0 459n 1.0 460n 0.0 650n 0.0]

XDUT (a b en y) logic_assign_xor_flag

tran tran stop=650n
save a b en y
