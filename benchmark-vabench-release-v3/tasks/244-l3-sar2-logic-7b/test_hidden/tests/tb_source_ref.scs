simulator lang=spectre
global 0
ahdl_include "l3_sar2_logic_7b.va"
Vclk (clk 0) vsource type=pulse val0=0 val1=0.9 delay=0.55n period=20n width=7.5n rise=20p fall=20p
Vdp (dp 0) vsource type=pwl wave=[0 0.9 1.10n 0.9 1.12n 0 1.42n 0 1.44n 0.9 2.50n 0.9 2.52n 0 2.82n 0 2.84n 0.9 3.20n 0.9 3.22n 0 3.52n 0 3.54n 0.9 5.30n 0.9 5.32n 0 5.62n 0 5.64n 0.9 6.4n 0.9]
Vdn (dn 0) vsource type=pwl wave=[0 0.9 1.80n 0.9 1.82n 0 2.12n 0 2.14n 0.9 3.90n 0.9 3.92n 0 4.22n 0 4.24n 0.9 4.60n 0.9 4.62n 0 4.92n 0 4.94n 0.9 6.4n 0.9]
XDUT (clk dp dn cmpck do0 do1 do2 do3 do4 do5 do6 sp1 sp2 sp3 sp4 sp5 sp6 sn1 sn2 sn3 sn4 sn5 sn6) l3_sar2_logic_7b
tran tran stop=6.4n maxstep=10p
save clk dp dn cmpck do0 do1 do2 do3 do4 do5 do6 sp1 sp2 sp3 sp4 sp5 sp6 sn1 sn2 sn3 sn4 sn5 sn6
