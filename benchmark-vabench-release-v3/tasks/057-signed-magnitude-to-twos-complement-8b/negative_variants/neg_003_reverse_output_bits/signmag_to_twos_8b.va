`include "constants.vams"
`include "disciplines.vams"

module signmag_to_twos_8b(
    sign,
    mag6,
    mag5,
    mag4,
    mag3,
    mag2,
    mag1,
    mag0,
    y7,
    y6,
    y5,
    y4,
    y3,
    y2,
    y1,
    y0
);
    input sign, mag6, mag5, mag4, mag3, mag2, mag1, mag0;
    output y7, y6, y5, y4, y3, y2, y1, y0;
    electrical sign, mag6, mag5, mag4, mag3, mag2, mag1, mag0, y7, y6, y5, y4, y3, y2, y1, y0;
    parameter real vdd = 0.9;
    parameter real vth = 0.45;
    parameter real tr = 20p;
    analog begin
        V(y7) <+ transition(V(mag0) > vth ? vdd : 0.0, 0, tr, tr);
        V(y6) <+ transition(0.0, 0, tr, tr);
        V(y5) <+ transition(0.0, 0, tr, tr);
        V(y4) <+ transition(0.0, 0, tr, tr);
        V(y3) <+ transition(0.0, 0, tr, tr);
        V(y2) <+ transition(0.0, 0, tr, tr);
        V(y1) <+ transition(0.0, 0, tr, tr);
        V(y0) <+ transition(0.0, 0, tr, tr);
    end
endmodule
