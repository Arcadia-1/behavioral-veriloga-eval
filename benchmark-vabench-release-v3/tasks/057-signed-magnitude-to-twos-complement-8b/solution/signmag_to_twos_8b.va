`include "constants.vams"
`include "disciplines.vams"

module signmag_to_twos_8b(
    sign,
    mag6,
    mag5,
    mag4,
    mag3,
    mag2,
    mag1,
    mag0,
    y7,
    y6,
    y5,
    y4,
    y3,
    y2,
    y1,
    y0
);
    input sign, mag6, mag5, mag4, mag3, mag2, mag1, mag0;
    output y7, y6, y5, y4, y3, y2, y1, y0;
    electrical sign, mag6, mag5, mag4, mag3, mag2, mag1, mag0, y7, y6, y5, y4, y3, y2, y1, y0;
    parameter real vdd = 0.9;
    parameter real vth = 0.45;
    parameter real tr = 20p;
    integer mag;
    integer y;
    analog begin
        mag = 0;
        if (V(mag0) > vth) mag = mag + 1;
        if (V(mag1) > vth) mag = mag + 2;
        if (V(mag2) > vth) mag = mag + 4;
        if (V(mag3) > vth) mag = mag + 8;
        if (V(mag4) > vth) mag = mag + 16;
        if (V(mag5) > vth) mag = mag + 32;
        if (V(mag6) > vth) mag = mag + 64;
        if (V(sign) > vth && mag != 0) y = 256 - mag;
        else y = mag;
        V(y0) <+ transition(((((y >> 0) & 1) != 0) ? vdd : 0.0), 0, tr, tr);
        V(y1) <+ transition(((((y >> 1) & 1) != 0) ? vdd : 0.0), 0, tr, tr);
        V(y2) <+ transition(((((y >> 2) & 1) != 0) ? vdd : 0.0), 0, tr, tr);
        V(y3) <+ transition(((((y >> 3) & 1) != 0) ? vdd : 0.0), 0, tr, tr);
        V(y4) <+ transition(((((y >> 4) & 1) != 0) ? vdd : 0.0), 0, tr, tr);
        V(y5) <+ transition(((((y >> 5) & 1) != 0) ? vdd : 0.0), 0, tr, tr);
        V(y6) <+ transition(((((y >> 6) & 1) != 0) ? vdd : 0.0), 0, tr, tr);
        V(y7) <+ transition(((((y >> 7) & 1) != 0) ? vdd : 0.0), 0, tr, tr);
    end
endmodule
