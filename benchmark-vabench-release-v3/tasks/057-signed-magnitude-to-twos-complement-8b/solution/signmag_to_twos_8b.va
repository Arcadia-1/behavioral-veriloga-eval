`include "constants.vams"
`include "disciplines.vams"

module signmag_to_twos_8b(
    input electrical sign,
    input electrical [6:0] mag,
    output electrical [7:0] y
);
    parameter real vdd = 0.9;
    parameter real vth = 0.45;
    parameter real tr = 20p;

    integer magnitude;
    integer value;
    integer j;
    genvar i;

    analog begin
        magnitude = 0;
        for (j = 0; j < 7; j = j + 1) if (V(mag[j]) > vth) magnitude = magnitude + (1 << j);
        if ((V(sign) > vth) && (magnitude != 0)) value = 256 - magnitude;
        else value = magnitude;
        for (i = 0; i < 8; i = i + 1) begin
            V(y[i]) <+ transition((((value / (1 << i)) % 2) != 0) ? vdd : 0.0, 0, tr, tr);
        end
    end
endmodule
