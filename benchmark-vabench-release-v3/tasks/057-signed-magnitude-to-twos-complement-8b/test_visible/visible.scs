simulator lang=spectre
global 0

ahdl_include "signmag_to_twos_8b.va"

Vmag0 (mag0 0) vsource type=pwl wave=[0 0 9.5n 0 10n 0.9 19.5n 0.9 20n 0.9 29.5n 0.9 30n 0 39.5n 0 40n 0 49.5n 0 50n 0.9 59.5n 0.9 60n 0.9 69.5n 0.9 70n 0.9 79.5n 0.9 80n 0.9 89.5n 0.9 90n 0 99.5n 0]
Vmag1 (mag1 0) vsource type=pwl wave=[0 0 9.5n 0 10n 0 19.5n 0 20n 0 29.5n 0 30n 0.9 39.5n 0.9 40n 0.9 49.5n 0.9 50n 0.9 59.5n 0.9 60n 0.9 69.5n 0.9 70n 0.9 79.5n 0.9 80n 0.9 89.5n 0.9 90n 0 99.5n 0]
Vmag2 (mag2 0) vsource type=pwl wave=[0 0 9.5n 0 10n 0 19.5n 0 20n 0 29.5n 0 30n 0 39.5n 0 40n 0 49.5n 0 50n 0.9 59.5n 0.9 60n 0.9 69.5n 0.9 70n 0.9 79.5n 0.9 80n 0.9 89.5n 0.9 90n 0 99.5n 0]
Vmag3 (mag3 0) vsource type=pwl wave=[0 0 9.5n 0 10n 0 19.5n 0 20n 0 29.5n 0 30n 0 39.5n 0 40n 0 49.5n 0 50n 0.9 59.5n 0.9 60n 0.9 69.5n 0.9 70n 0.9 79.5n 0.9 80n 0.9 89.5n 0.9 90n 0 99.5n 0]
Vmag4 (mag4 0) vsource type=pwl wave=[0 0 9.5n 0 10n 0 19.5n 0 20n 0 29.5n 0 30n 0 39.5n 0 40n 0 49.5n 0 50n 0.9 59.5n 0.9 60n 0.9 69.5n 0.9 70n 0.9 79.5n 0.9 80n 0.9 89.5n 0.9 90n 0 99.5n 0]
Vmag5 (mag5 0) vsource type=pwl wave=[0 0 9.5n 0 10n 0 19.5n 0 20n 0 29.5n 0 30n 0 39.5n 0 40n 0 49.5n 0 50n 0.9 59.5n 0.9 60n 0.9 69.5n 0.9 70n 0.9 79.5n 0.9 80n 0.9 89.5n 0.9 90n 0 99.5n 0]
Vmag6 (mag6 0) vsource type=pwl wave=[0 0 9.5n 0 10n 0 19.5n 0 20n 0 29.5n 0 30n 0 39.5n 0 40n 0 49.5n 0 50n 0 59.5n 0 60n 0 69.5n 0 70n 0.9 79.5n 0.9 80n 0.9 89.5n 0.9 90n 0 99.5n 0]
Vsign (sign 0) vsource type=pwl wave=[0 0 9.5n 0 10n 0 19.5n 0 20n 0.9 29.5n 0.9 30n 0 39.5n 0 40n 0.9 49.5n 0.9 50n 0 59.5n 0 60n 0.9 69.5n 0.9 70n 0 79.5n 0 80n 0.9 89.5n 0.9 90n 0.9 99.5n 0.9]

XDUT (sign mag6 mag5 mag4 mag3 mag2 mag1 mag0 y7 y6 y5 y4 y3 y2 y1 y0) signmag_to_twos_8b

tran tran stop=105n maxstep=100p
save sign mag0 mag1 mag2 mag3 mag4 mag5 mag6 y0 y1 y2 y3 y4 y5 y6 y7
