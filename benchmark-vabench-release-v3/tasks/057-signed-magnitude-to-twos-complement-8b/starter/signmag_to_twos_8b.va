`include "constants.vams"
`include "disciplines.vams"

module signmag_to_twos_8b(
    input electrical sign,
    input electrical [6:0] mag,
    output electrical [7:0] y
);
    parameter real vdd = 0.9;
    parameter real vth = 0.45;
    parameter real tr = 20p;
    genvar i;
    analog begin
        for (i = 0; i < 8; i = i + 1) V(y[i]) <+ transition(0.0, 0, tr, tr);
    end
endmodule
