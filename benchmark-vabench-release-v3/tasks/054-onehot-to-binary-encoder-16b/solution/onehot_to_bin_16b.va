`include "constants.vams"
`include "disciplines.vams"

module onehot_to_bin_16b(
    oh15,
    oh14,
    oh13,
    oh12,
    oh11,
    oh10,
    oh9,
    oh8,
    oh7,
    oh6,
    oh5,
    oh4,
    oh3,
    oh2,
    oh1,
    oh0,
    b3,
    b2,
    b1,
    b0,
    valid
);
    input oh15, oh14, oh13, oh12, oh11, oh10, oh9, oh8, oh7, oh6, oh5, oh4, oh3, oh2, oh1, oh0;
    output b3, b2, b1, b0, valid;
    electrical oh15, oh14, oh13, oh12, oh11, oh10, oh9, oh8, oh7, oh6, oh5, oh4, oh3, oh2, oh1, oh0, b3, b2, b1, b0, valid;
    parameter real vdd = 0.9;
    parameter real vth = 0.45;
    parameter real tr = 20p;
    integer count;
    integer idx;
    analog begin
        count = 0;
        idx = 0;
        if (V(oh0) > vth) begin
            count = count + 1;
            idx = 0;
        end
        if (V(oh1) > vth) begin
            count = count + 1;
            idx = 1;
        end
        if (V(oh2) > vth) begin
            count = count + 1;
            idx = 2;
        end
        if (V(oh3) > vth) begin
            count = count + 1;
            idx = 3;
        end
        if (V(oh4) > vth) begin
            count = count + 1;
            idx = 4;
        end
        if (V(oh5) > vth) begin
            count = count + 1;
            idx = 5;
        end
        if (V(oh6) > vth) begin
            count = count + 1;
            idx = 6;
        end
        if (V(oh7) > vth) begin
            count = count + 1;
            idx = 7;
        end
        if (V(oh8) > vth) begin
            count = count + 1;
            idx = 8;
        end
        if (V(oh9) > vth) begin
            count = count + 1;
            idx = 9;
        end
        if (V(oh10) > vth) begin
            count = count + 1;
            idx = 10;
        end
        if (V(oh11) > vth) begin
            count = count + 1;
            idx = 11;
        end
        if (V(oh12) > vth) begin
            count = count + 1;
            idx = 12;
        end
        if (V(oh13) > vth) begin
            count = count + 1;
            idx = 13;
        end
        if (V(oh14) > vth) begin
            count = count + 1;
            idx = 14;
        end
        if (V(oh15) > vth) begin
            count = count + 1;
            idx = 15;
        end
        V(b0) <+ transition((count == 1 && (((idx >> 0) & 1) != 0)) ? vdd : 0.0, 0, tr, tr);
        V(b1) <+ transition((count == 1 && (((idx >> 1) & 1) != 0)) ? vdd : 0.0, 0, tr, tr);
        V(b2) <+ transition((count == 1 && (((idx >> 2) & 1) != 0)) ? vdd : 0.0, 0, tr, tr);
        V(b3) <+ transition((count == 1 && (((idx >> 3) & 1) != 0)) ? vdd : 0.0, 0, tr, tr);
        V(valid) <+ transition((count == 1) ? vdd : 0.0, 0, tr, tr);
    end
endmodule
