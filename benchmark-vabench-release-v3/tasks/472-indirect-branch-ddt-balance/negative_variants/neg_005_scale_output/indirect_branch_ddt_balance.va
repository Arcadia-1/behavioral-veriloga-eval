`include "constants.vams"
`include "disciplines.vams"

module indirect_branch_ddt_balance (input electrical in, output electrical out);
analog begin
    V(out) : ddt(V(out)) + 0.1 == V(in);
end
endmodule
