`include "constants.vams"
`include "disciplines.vams"

module indirect_branch_ddt_balance (
    input  electrical in,
    output electrical out
);
parameter real tau = 20n from (0:inf);
analog begin
    V(out) : ddt(V(out)) == (V(in) - V(out)) / tau;
end
endmodule
