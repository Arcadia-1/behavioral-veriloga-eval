simulator lang=spectre
global 0

ahdl_include "bbpd_ref.va"

V_data (data 0) vsource type=pulse val0=0 val1=0.9 period=3n delay=0p rise=50p fall=50p width=1.4n
V_clk (clk 0) vsource type=pulse val0=0 val1=0.9 period=1n delay=100p rise=20p fall=20p width=450p
V_retimed_data (retimed_data 0) vsource type=pulse val0=0 val1=0.9 period=3n delay=200p rise=50p fall=50p width=1.4n

XDUT (data clk retimed_data up down) bbpd_ref

tran tran stop=5n maxstep=100p
save data clk retimed_data up down
