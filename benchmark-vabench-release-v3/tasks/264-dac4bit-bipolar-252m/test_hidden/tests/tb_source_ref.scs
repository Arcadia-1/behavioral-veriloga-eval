simulator lang=spectre
global 0
ahdl_include "dac4bit_bipolar_252m.va"
Vd0 (d0 0) vsource type=pwl wave=[0 0.9 0.8n 0.9 0.85n 0 1.6n 0 1.65n 0.9 2.4n 0.9 2.45n 0 3.3n 0]
Vd1 (d1 0) vsource type=pwl wave=[0 0.9 0.8n 0.9 0.85n 0 1.6n 0 1.65n 0 2.4n 0 2.45n 0.9 3.3n 0.9]
Vd2 (d2 0) vsource type=pwl wave=[0 0.9 0.8n 0.9 0.85n 0 1.6n 0 1.65n 0.9 2.4n 0.9 2.45n 0 3.3n 0]
Vd3 (d3 0) vsource type=pwl wave=[0 0.9 1.6n 0.9 1.65n 0 2.4n 0 2.45n 0.9 3.3n 0.9]
XDUT (d3 d2 d1 d0 vout) dac4bit_bipolar_252m
tran tran stop=3.2n maxstep=5p
save d3 d2 d1 d0 vout
