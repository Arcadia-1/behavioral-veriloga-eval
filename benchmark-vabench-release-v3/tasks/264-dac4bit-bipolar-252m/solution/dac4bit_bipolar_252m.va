`include "disciplines.vams"
module dac4bit_bipolar_252m(d3, d2, d1, d0, vout);
input d3, d2, d1, d0;
output vout;
electrical d3, d2, d1, d0, vout;
parameter real vref = 252m;
parameter real vtrans = 0.45;
parameter real tdel = 0;
parameter real trise = 1p;
parameter real tfall = 1p;
real out_scaled;
real vout_level;
analog begin
    @(initial_step or cross(V(d3) - vtrans, 0) or cross(V(d2) - vtrans, 0) or
      cross(V(d1) - vtrans, 0) or cross(V(d0) - vtrans, 0)) begin
        out_scaled = 0;
        out_scaled = out_scaled + ((V(d3) > vtrans) ? 8 : 0);
        out_scaled = out_scaled + ((V(d2) > vtrans) ? 4 : 0);
        out_scaled = out_scaled + ((V(d1) > vtrans) ? 2 : 0);
        out_scaled = out_scaled + ((V(d0) > vtrans) ? 1 : 0);
        vout_level = vref * (2.0 * out_scaled / 15.0 - 1.0);
    end
    V(vout) <+ transition(vout_level, tdel, trise, tfall);
end
endmodule
