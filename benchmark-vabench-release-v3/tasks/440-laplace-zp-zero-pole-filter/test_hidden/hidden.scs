simulator lang=spectre
global 0

ahdl_include "laplace_zp_zero_pole_filter.va"

Vvin (vin 0) vsource type=pwl wave=[0 0.0 110n 0.0 111n 0.9 280n 0.9 281n 0.2 500n 0.2]
Vclk (clk 0) vsource type=pwl wave=[0 0.0 99n 0.0 100n 1.0 149n 1.0 150n 0.0 249n 0.0 250n 1.0 299n 1.0 300n 0.0]
Vmode (mode 0) vsource dc=0.0
Vrst (rst 0) vsource dc=0.0

XDUT (vin clk mode rst out metric) laplace_zp_zero_pole_filter

tran tran stop=500n
save vin clk mode rst out metric
