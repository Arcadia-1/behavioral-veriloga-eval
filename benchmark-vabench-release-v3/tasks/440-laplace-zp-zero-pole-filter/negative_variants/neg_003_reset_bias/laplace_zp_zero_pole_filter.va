`include "constants.vams"
`include "disciplines.vams"

module laplace_zp_zero_pole_filter (
    input  electrical vin,
    input  electrical clk,
    input  electrical mode,
    input  electrical rst,
    output electrical out,
    output electrical metric
);
parameter real vth = 0.45;
parameter real vhi = 0.9;
parameter real tr = 200p;
real out_v;
real metric_v;
integer count_q;
analog begin
    @(initial_step) begin
        out_v = 0.0;
        metric_v = 0.0;
        count_q = 0;
    end
    @(cross(V(clk) - vth, +1)) begin
        if (V(rst) > vth) begin
            out_v = 0.0;
            metric_v = 0.0;
            count_q = 0;
        end else begin
            out_v = laplace_zp(V(vin), {1.0}, {1.0, 1.0});
            metric_v = out_v;
            count_q = count_q + 1;
            out_v = (V(rst) > 0.45 ? 0.25 : (out_v));
            metric_v = (V(rst) > 0.45 ? 0.25 : (metric_v));
        end
    end
    V(out) <+ transition(out_v, 0.0, tr, tr);
    V(metric) <+ transition(metric_v, 0.0, tr, tr);
end
endmodule
