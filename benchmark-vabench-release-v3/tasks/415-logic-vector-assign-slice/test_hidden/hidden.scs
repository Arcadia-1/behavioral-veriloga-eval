simulator lang=spectre
global 0

ahdl_include "logic_vector_assign_slice.vams"

Vcode0 (code0 0) vsource type=pwl wave=[0 0.0 149n 0.0 150n 1.0 349n 1.0 350n 0.0 500n 0.0]
Vcode1 (code1 0) vsource type=pwl wave=[0 1.0 124n 1.0 125n 0.0 500n 0.0]
Vcode2 (code2 0) vsource type=pwl wave=[0 1.0 99n 1.0 100n 0.0 299n 0.0 300n 1.0 500n 1.0]
Vcode3 (code3 0) vsource type=pwl wave=[0 0.0 399n 0.0 400n 1.0 500n 1.0]
Vsel (sel 0) vsource type=pwl wave=[0 1.0 124n 1.0 125n 0.0 274n 0.0 275n 1.0 424n 1.0 425n 0.0 500n 0.0]

XDUT (code3 code2 code1 code0 sel y) logic_vector_assign_slice

tran tran stop=500n
save code0 code1 code2 code3 sel y
