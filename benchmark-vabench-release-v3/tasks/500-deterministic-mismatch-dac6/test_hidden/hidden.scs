simulator lang=spectre
global 0

ahdl_include "deterministic_mismatch_dac6.va"

Vd5 (d5 0) vsource type=pwl wave=[0n 0 5.2n 0 5.22n 0.9]
Vd4 (d4 0) vsource type=pwl wave=[0n 0 3.2n 0 3.22n 0.9 5.2n 0.9 5.22n 0 9.2n 0 9.22n 0.9]
Vd3 (d3 0) vsource type=pwl wave=[0n 0 7.2n 0 7.22n 0.9]
Vd2 (d2 0) vsource type=pwl wave=[0n 0 7.2n 0 7.22n 0.9]
Vd1 (d1 0) vsource type=pwl wave=[0n 0 1.2n 0 1.22n 0.9 3.2n 0.9 3.22n 0 5.2n 0 5.22n 0.9 7.2n 0.9 7.22n 0 9.2n 0 9.22n 0.9]
Vd0 (d0 0) vsource type=pwl wave=[0n 0 1.2n 0 1.22n 0.9 5.2n 0.9 5.22n 0 7.2n 0 7.22n 0.9 9.2n 0.9 9.22n 0 11.2n 0 11.22n 0.9]

XDUT (d5 d4 d3 d2 d1 d0 vout) deterministic_mismatch_dac6

tran tran stop=13n maxstep=10p
save d5 d4 d3 d2 d1 d0 vout
