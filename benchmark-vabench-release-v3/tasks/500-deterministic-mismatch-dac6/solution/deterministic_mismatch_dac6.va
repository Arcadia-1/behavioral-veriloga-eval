`include "disciplines.vams"

module deterministic_mismatch_dac6(d5, d4, d3, d2, d1, d0, vout);
input d5, d4, d3, d2, d1, d0;
output vout;
electrical d5, d4, d3, d2, d1, d0, vout;

parameter real vth = 0.45;
parameter real vref = 1.0;
parameter real tr = 20p;
parameter real m5 = 0.08;
parameter real m4 = -0.06;
parameter real m3 = 0.04;
parameter real m2 = -0.03;
parameter real m1 = 0.025;
parameter real m0 = -0.015;

real w5, w4, w3, w2, w1, w0;
real active;
real total;
real target;

analog begin
    w5 = 32.0 * (1.0 + m5);
    w4 = 16.0 * (1.0 + m4);
    w3 = 8.0 * (1.0 + m3);
    w2 = 4.0 * (1.0 + m2);
    w1 = 2.0 * (1.0 + m1);
    w0 = 1.0 * (1.0 + m0);

    active = ((V(d5) > vth) ? w5 : 0.0)
           + ((V(d4) > vth) ? w4 : 0.0)
           + ((V(d3) > vth) ? w3 : 0.0)
           + ((V(d2) > vth) ? w2 : 0.0)
           + ((V(d1) > vth) ? w1 : 0.0)
           + ((V(d0) > vth) ? w0 : 0.0);
    total = w5 + w4 + w3 + w2 + w1 + w0;
    target = vref * active / total;
    V(vout) <+ transition(target, 0, tr, tr);
end
endmodule
