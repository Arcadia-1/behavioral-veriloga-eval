`include "disciplines.vams"

module deterministic_mismatch_dac6(d5, d4, d3, d2, d1, d0, vout);
input d5, d4, d3, d2, d1, d0;
output vout;
electrical d5, d4, d3, d2, d1, d0, vout;

analog begin
    V(vout) <+ 0.0;
end
endmodule
