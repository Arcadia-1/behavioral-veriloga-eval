simulator lang=spectre
global 0
// Visible smoke skeleton for noise/analysis extension task.
tran tran stop=80n
