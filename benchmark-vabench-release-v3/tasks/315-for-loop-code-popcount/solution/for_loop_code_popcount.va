`include "constants.vams"
`include "disciplines.vams"

module for_loop_code_popcount (
    input  electrical vin,
    input  electrical clk,
    input  electrical mode,
    input  electrical rst,
    output electrical out,
    output electrical metric
);
parameter real vth = 0.45;
parameter real vhi = 0.9;
parameter real tr = 200p;
real out_v;
real metric_v;
integer count_q;
integer state_q;
integer bits[0:3];
integer i;
analog begin
    @(initial_step) begin
        out_v = 0.0;
        metric_v = 0.0;
        count_q = 0;
        state_q = 0;
        for (i = 0; i < 4; i = i + 1) begin
            bits[i] = 0;
        end
    end
    @(cross(V(clk) - vth, +1) or cross(V(rst) - vth, +1)) begin
        if (V(rst) > vth) begin
            count_q = 0;
            out_v = 0.0;
            metric_v = 0.0;
            for (i = 0; i < 4; i = i + 1) begin
                bits[i] = 0;
            end
        end else begin
            bits[0] = (V(vin) > 0.20) ? 1 : 0;
            bits[1] = (V(vin) > 0.60) ? 1 : 0;
            bits[2] = (V(mode) > 0.20) ? 1 : 0;
            bits[3] = (V(mode) > 0.60) ? 1 : 0;
            count_q = 0;
            for (i = 0; i < 4; i = i + 1) begin
                count_q = count_q + bits[i];
            end
            out_v = 0.9 * count_q / 4.0;
            metric_v = count_q / 4.0;
        end
    end
    V(out) <+ transition(out_v, 0.0, tr, tr);
    V(metric) <+ transition(metric_v, 0.0, tr, tr);
end
endmodule
