simulator lang=spectre
global 0

ahdl_include "above_threshold_latch.va"

Vvin (vin 0) vsource type=pwl wave=[0 0.1 79n 0.1 80n 0.75 150n 0.75 151n 0.1 259n 0.1 260n 0.82 340n 0.82 341n 0.1 579n 0.1 580n 0.78 700n 0.78]
Vmode (mode 0) vsource dc=0.0 type=dc
Vrst (rst 0) vsource type=pwl wave=[0 0.0 419n 0.0 420n 0.9 449n 0.9 450n 0.0 700n 0.0]
Vclk (clk 0) vsource dc=0.0 type=dc

XDUT (vin clk mode rst out metric) above_threshold_latch

tran tran stop=700n
save vin clk mode rst out metric
