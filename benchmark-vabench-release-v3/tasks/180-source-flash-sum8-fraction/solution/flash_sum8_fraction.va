`include "disciplines.vams"

module flash_sum8_fraction(din0, din1, din2, din3, din4, din5, din6, din7, clks, dout);
input din0, din1, din2, din3, din4, din5, din6, din7, clks;
output dout;
electrical din0, din1, din2, din3, din4, din5, din6, din7, clks, dout;

parameter real vth = 0.45;
real dreg;

analog begin
    @(initial_step) dreg = 0;
    @(cross(V(clks) - vth, +1)) begin
        dreg = ((V(din0)>vth) + (V(din1)>vth) + (V(din2)>vth) + (V(din3)>vth)
              + (V(din4)>vth) + (V(din5)>vth) + (V(din6)>vth) + (V(din7)>vth)) / 8.0;
    end
    V(dout) <+ transition(dreg, 1p, 1p, 1p);
end

endmodule
