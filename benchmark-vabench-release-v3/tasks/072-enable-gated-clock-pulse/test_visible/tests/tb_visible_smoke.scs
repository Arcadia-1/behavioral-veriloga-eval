simulator lang=spectre
global 0

ahdl_include "enable_gated_clock_pulse.va"

V_clk (clk 0) vsource type=pulse val0=0 val1=0.9 period=1n delay=100p rise=20p fall=20p width=450p
V_en (en 0) vsource type=pulse val0=0 val1=0.9 period=4n delay=400p rise=50p fall=50p width=1.5n

XDUT (clk en pulse) enable_gated_clock_pulse

tran tran stop=8n maxstep=100p
save clk en pulse
