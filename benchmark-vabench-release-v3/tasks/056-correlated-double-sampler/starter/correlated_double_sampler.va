`include "disciplines.vams"

module correlated_double_sampler(phi_reset, phi_signal, vin, vout, valid);
input phi_reset, phi_signal, vin;
output vout, valid;
electrical phi_reset, phi_signal, vin, vout, valid;

parameter real vth = 0.45;
parameter real vcm = 0.45;
parameter real gain = 1.0;
parameter real vlo = 0.0;
parameter real vhi = 0.9;
parameter real tr = 100p from [0:inf);

analog begin
    // TODO: implement reset-phase sampling, signal-phase correction, valid state,
    // and held smoothed voltage outputs.
    V(vout) <+ transition(vcm, 0, tr, tr);
    V(valid) <+ transition(0.0, 0, tr, tr);
end
endmodule
