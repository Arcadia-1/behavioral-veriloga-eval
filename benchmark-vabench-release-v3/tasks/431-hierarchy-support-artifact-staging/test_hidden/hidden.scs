simulator lang=spectre
global 0

ahdl_include "staged_gain_child.va"
ahdl_include "staged_limit_child.va"
ahdl_include "hierarchy_support_artifact_staging.va"

Vvin (vin 0) vsource type=pwl wave=[0 0.20 79n 0.20 80n 0.95 169n 0.95 170n 1.60 260n 1.60]
Vclk (clk 0) vsource dc=0.0
Vmode (mode 0) vsource dc=0.0
Vrst (rst 0) vsource type=pwl wave=[0 0.0 189n 0.0 190n 1.0 229n 1.0 230n 0.0 260n 0.0]

XDUT (vin clk mode rst out metric) hierarchy_support_artifact_staging

tran tran stop=260n
save vin clk mode rst out metric
