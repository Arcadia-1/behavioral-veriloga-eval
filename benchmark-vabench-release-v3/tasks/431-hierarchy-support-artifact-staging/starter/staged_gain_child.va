`include "constants.vams"
`include "disciplines.vams"

module staged_gain_child(input electrical vin, output electrical out);
parameter real gain = 1.0;
analog begin
    V(out) <+ gain * V(vin);
end
endmodule
