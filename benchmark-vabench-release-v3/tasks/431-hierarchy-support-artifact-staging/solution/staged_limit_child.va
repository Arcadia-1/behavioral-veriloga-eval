`include "constants.vams"
`include "disciplines.vams"

module staged_limit_child(input electrical vin, output electrical out);
analog begin
    V(out) <+ 0.5 * (V(vin) + 0.9 - abs(V(vin) - 0.9));
end
endmodule
