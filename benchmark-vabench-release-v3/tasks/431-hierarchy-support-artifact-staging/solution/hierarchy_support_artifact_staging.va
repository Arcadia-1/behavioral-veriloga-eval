`include "constants.vams"
`include "disciplines.vams"

module hierarchy_support_artifact_staging (
    input  electrical vin,
    input  electrical clk,
    input  electrical mode,
    input  electrical rst,
    output electrical out,
    output electrical metric
);
electrical mid;
    staged_gain_child #(.gain(0.75)) u_gain(.vin(vin), .out(mid));
    staged_limit_child u_limit(.vin(mid), .out(out));
analog begin
    V(metric) <+ V(mid);
end
endmodule
