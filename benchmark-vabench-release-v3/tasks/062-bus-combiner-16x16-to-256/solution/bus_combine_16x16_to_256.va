`include "constants.vams"
`include "disciplines.vams"

module bus_combine_16x16_to_256(
    in15_15,
    in15_14,
    in15_13,
    in15_12,
    in15_11,
    in15_10,
    in15_9,
    in15_8,
    in15_7,
    in15_6,
    in15_5,
    in15_4,
    in15_3,
    in15_2,
    in15_1,
    in15_0,
    in14_15,
    in14_14,
    in14_13,
    in14_12,
    in14_11,
    in14_10,
    in14_9,
    in14_8,
    in14_7,
    in14_6,
    in14_5,
    in14_4,
    in14_3,
    in14_2,
    in14_1,
    in14_0,
    in13_15,
    in13_14,
    in13_13,
    in13_12,
    in13_11,
    in13_10,
    in13_9,
    in13_8,
    in13_7,
    in13_6,
    in13_5,
    in13_4,
    in13_3,
    in13_2,
    in13_1,
    in13_0,
    in12_15,
    in12_14,
    in12_13,
    in12_12,
    in12_11,
    in12_10,
    in12_9,
    in12_8,
    in12_7,
    in12_6,
    in12_5,
    in12_4,
    in12_3,
    in12_2,
    in12_1,
    in12_0,
    in11_15,
    in11_14,
    in11_13,
    in11_12,
    in11_11,
    in11_10,
    in11_9,
    in11_8,
    in11_7,
    in11_6,
    in11_5,
    in11_4,
    in11_3,
    in11_2,
    in11_1,
    in11_0,
    in10_15,
    in10_14,
    in10_13,
    in10_12,
    in10_11,
    in10_10,
    in10_9,
    in10_8,
    in10_7,
    in10_6,
    in10_5,
    in10_4,
    in10_3,
    in10_2,
    in10_1,
    in10_0,
    in9_15,
    in9_14,
    in9_13,
    in9_12,
    in9_11,
    in9_10,
    in9_9,
    in9_8,
    in9_7,
    in9_6,
    in9_5,
    in9_4,
    in9_3,
    in9_2,
    in9_1,
    in9_0,
    in8_15,
    in8_14,
    in8_13,
    in8_12,
    in8_11,
    in8_10,
    in8_9,
    in8_8,
    in8_7,
    in8_6,
    in8_5,
    in8_4,
    in8_3,
    in8_2,
    in8_1,
    in8_0,
    in7_15,
    in7_14,
    in7_13,
    in7_12,
    in7_11,
    in7_10,
    in7_9,
    in7_8,
    in7_7,
    in7_6,
    in7_5,
    in7_4,
    in7_3,
    in7_2,
    in7_1,
    in7_0,
    in6_15,
    in6_14,
    in6_13,
    in6_12,
    in6_11,
    in6_10,
    in6_9,
    in6_8,
    in6_7,
    in6_6,
    in6_5,
    in6_4,
    in6_3,
    in6_2,
    in6_1,
    in6_0,
    in5_15,
    in5_14,
    in5_13,
    in5_12,
    in5_11,
    in5_10,
    in5_9,
    in5_8,
    in5_7,
    in5_6,
    in5_5,
    in5_4,
    in5_3,
    in5_2,
    in5_1,
    in5_0,
    in4_15,
    in4_14,
    in4_13,
    in4_12,
    in4_11,
    in4_10,
    in4_9,
    in4_8,
    in4_7,
    in4_6,
    in4_5,
    in4_4,
    in4_3,
    in4_2,
    in4_1,
    in4_0,
    in3_15,
    in3_14,
    in3_13,
    in3_12,
    in3_11,
    in3_10,
    in3_9,
    in3_8,
    in3_7,
    in3_6,
    in3_5,
    in3_4,
    in3_3,
    in3_2,
    in3_1,
    in3_0,
    in2_15,
    in2_14,
    in2_13,
    in2_12,
    in2_11,
    in2_10,
    in2_9,
    in2_8,
    in2_7,
    in2_6,
    in2_5,
    in2_4,
    in2_3,
    in2_2,
    in2_1,
    in2_0,
    in1_15,
    in1_14,
    in1_13,
    in1_12,
    in1_11,
    in1_10,
    in1_9,
    in1_8,
    in1_7,
    in1_6,
    in1_5,
    in1_4,
    in1_3,
    in1_2,
    in1_1,
    in1_0,
    in0_15,
    in0_14,
    in0_13,
    in0_12,
    in0_11,
    in0_10,
    in0_9,
    in0_8,
    in0_7,
    in0_6,
    in0_5,
    in0_4,
    in0_3,
    in0_2,
    in0_1,
    in0_0,
    out255,
    out254,
    out253,
    out252,
    out251,
    out250,
    out249,
    out248,
    out247,
    out246,
    out245,
    out244,
    out243,
    out242,
    out241,
    out240,
    out239,
    out238,
    out237,
    out236,
    out235,
    out234,
    out233,
    out232,
    out231,
    out230,
    out229,
    out228,
    out227,
    out226,
    out225,
    out224,
    out223,
    out222,
    out221,
    out220,
    out219,
    out218,
    out217,
    out216,
    out215,
    out214,
    out213,
    out212,
    out211,
    out210,
    out209,
    out208,
    out207,
    out206,
    out205,
    out204,
    out203,
    out202,
    out201,
    out200,
    out199,
    out198,
    out197,
    out196,
    out195,
    out194,
    out193,
    out192,
    out191,
    out190,
    out189,
    out188,
    out187,
    out186,
    out185,
    out184,
    out183,
    out182,
    out181,
    out180,
    out179,
    out178,
    out177,
    out176,
    out175,
    out174,
    out173,
    out172,
    out171,
    out170,
    out169,
    out168,
    out167,
    out166,
    out165,
    out164,
    out163,
    out162,
    out161,
    out160,
    out159,
    out158,
    out157,
    out156,
    out155,
    out154,
    out153,
    out152,
    out151,
    out150,
    out149,
    out148,
    out147,
    out146,
    out145,
    out144,
    out143,
    out142,
    out141,
    out140,
    out139,
    out138,
    out137,
    out136,
    out135,
    out134,
    out133,
    out132,
    out131,
    out130,
    out129,
    out128,
    out127,
    out126,
    out125,
    out124,
    out123,
    out122,
    out121,
    out120,
    out119,
    out118,
    out117,
    out116,
    out115,
    out114,
    out113,
    out112,
    out111,
    out110,
    out109,
    out108,
    out107,
    out106,
    out105,
    out104,
    out103,
    out102,
    out101,
    out100,
    out99,
    out98,
    out97,
    out96,
    out95,
    out94,
    out93,
    out92,
    out91,
    out90,
    out89,
    out88,
    out87,
    out86,
    out85,
    out84,
    out83,
    out82,
    out81,
    out80,
    out79,
    out78,
    out77,
    out76,
    out75,
    out74,
    out73,
    out72,
    out71,
    out70,
    out69,
    out68,
    out67,
    out66,
    out65,
    out64,
    out63,
    out62,
    out61,
    out60,
    out59,
    out58,
    out57,
    out56,
    out55,
    out54,
    out53,
    out52,
    out51,
    out50,
    out49,
    out48,
    out47,
    out46,
    out45,
    out44,
    out43,
    out42,
    out41,
    out40,
    out39,
    out38,
    out37,
    out36,
    out35,
    out34,
    out33,
    out32,
    out31,
    out30,
    out29,
    out28,
    out27,
    out26,
    out25,
    out24,
    out23,
    out22,
    out21,
    out20,
    out19,
    out18,
    out17,
    out16,
    out15,
    out14,
    out13,
    out12,
    out11,
    out10,
    out9,
    out8,
    out7,
    out6,
    out5,
    out4,
    out3,
    out2,
    out1,
    out0
);
    input in15_15, in15_14, in15_13, in15_12, in15_11, in15_10, in15_9, in15_8, in15_7, in15_6, in15_5, in15_4, in15_3, in15_2, in15_1, in15_0, in14_15, in14_14, in14_13, in14_12, in14_11, in14_10, in14_9, in14_8, in14_7, in14_6, in14_5, in14_4, in14_3, in14_2, in14_1, in14_0, in13_15, in13_14, in13_13, in13_12, in13_11, in13_10, in13_9, in13_8, in13_7, in13_6, in13_5, in13_4, in13_3, in13_2, in13_1, in13_0, in12_15, in12_14, in12_13, in12_12, in12_11, in12_10, in12_9, in12_8, in12_7, in12_6, in12_5, in12_4, in12_3, in12_2, in12_1, in12_0, in11_15, in11_14, in11_13, in11_12, in11_11, in11_10, in11_9, in11_8, in11_7, in11_6, in11_5, in11_4, in11_3, in11_2, in11_1, in11_0, in10_15, in10_14, in10_13, in10_12, in10_11, in10_10, in10_9, in10_8, in10_7, in10_6, in10_5, in10_4, in10_3, in10_2, in10_1, in10_0, in9_15, in9_14, in9_13, in9_12, in9_11, in9_10, in9_9, in9_8, in9_7, in9_6, in9_5, in9_4, in9_3, in9_2, in9_1, in9_0, in8_15, in8_14, in8_13, in8_12, in8_11, in8_10, in8_9, in8_8, in8_7, in8_6, in8_5, in8_4, in8_3, in8_2, in8_1, in8_0, in7_15, in7_14, in7_13, in7_12, in7_11, in7_10, in7_9, in7_8, in7_7, in7_6, in7_5, in7_4, in7_3, in7_2, in7_1, in7_0, in6_15, in6_14, in6_13, in6_12, in6_11, in6_10, in6_9, in6_8, in6_7, in6_6, in6_5, in6_4, in6_3, in6_2, in6_1, in6_0, in5_15, in5_14, in5_13, in5_12, in5_11, in5_10, in5_9, in5_8, in5_7, in5_6, in5_5, in5_4, in5_3, in5_2, in5_1, in5_0, in4_15, in4_14, in4_13, in4_12, in4_11, in4_10, in4_9, in4_8, in4_7, in4_6, in4_5, in4_4, in4_3, in4_2, in4_1, in4_0, in3_15, in3_14, in3_13, in3_12, in3_11, in3_10, in3_9, in3_8, in3_7, in3_6, in3_5, in3_4, in3_3, in3_2, in3_1, in3_0, in2_15, in2_14, in2_13, in2_12, in2_11, in2_10, in2_9, in2_8, in2_7, in2_6, in2_5, in2_4, in2_3, in2_2, in2_1, in2_0, in1_15, in1_14, in1_13, in1_12, in1_11, in1_10, in1_9, in1_8, in1_7, in1_6, in1_5, in1_4, in1_3, in1_2, in1_1, in1_0, in0_15, in0_14, in0_13, in0_12, in0_11, in0_10, in0_9, in0_8, in0_7, in0_6, in0_5, in0_4, in0_3, in0_2, in0_1, in0_0;
    output out255, out254, out253, out252, out251, out250, out249, out248, out247, out246, out245, out244, out243, out242, out241, out240, out239, out238, out237, out236, out235, out234, out233, out232, out231, out230, out229, out228, out227, out226, out225, out224, out223, out222, out221, out220, out219, out218, out217, out216, out215, out214, out213, out212, out211, out210, out209, out208, out207, out206, out205, out204, out203, out202, out201, out200, out199, out198, out197, out196, out195, out194, out193, out192, out191, out190, out189, out188, out187, out186, out185, out184, out183, out182, out181, out180, out179, out178, out177, out176, out175, out174, out173, out172, out171, out170, out169, out168, out167, out166, out165, out164, out163, out162, out161, out160, out159, out158, out157, out156, out155, out154, out153, out152, out151, out150, out149, out148, out147, out146, out145, out144, out143, out142, out141, out140, out139, out138, out137, out136, out135, out134, out133, out132, out131, out130, out129, out128, out127, out126, out125, out124, out123, out122, out121, out120, out119, out118, out117, out116, out115, out114, out113, out112, out111, out110, out109, out108, out107, out106, out105, out104, out103, out102, out101, out100, out99, out98, out97, out96, out95, out94, out93, out92, out91, out90, out89, out88, out87, out86, out85, out84, out83, out82, out81, out80, out79, out78, out77, out76, out75, out74, out73, out72, out71, out70, out69, out68, out67, out66, out65, out64, out63, out62, out61, out60, out59, out58, out57, out56, out55, out54, out53, out52, out51, out50, out49, out48, out47, out46, out45, out44, out43, out42, out41, out40, out39, out38, out37, out36, out35, out34, out33, out32, out31, out30, out29, out28, out27, out26, out25, out24, out23, out22, out21, out20, out19, out18, out17, out16, out15, out14, out13, out12, out11, out10, out9, out8, out7, out6, out5, out4, out3, out2, out1, out0;
    electrical in15_15, in15_14, in15_13, in15_12, in15_11, in15_10, in15_9, in15_8, in15_7, in15_6, in15_5, in15_4, in15_3, in15_2, in15_1, in15_0, in14_15, in14_14, in14_13, in14_12, in14_11, in14_10, in14_9, in14_8, in14_7, in14_6, in14_5, in14_4, in14_3, in14_2, in14_1, in14_0, in13_15, in13_14, in13_13, in13_12, in13_11, in13_10, in13_9, in13_8, in13_7, in13_6, in13_5, in13_4, in13_3, in13_2, in13_1, in13_0, in12_15, in12_14, in12_13, in12_12, in12_11, in12_10, in12_9, in12_8, in12_7, in12_6, in12_5, in12_4, in12_3, in12_2, in12_1, in12_0, in11_15, in11_14, in11_13, in11_12, in11_11, in11_10, in11_9, in11_8, in11_7, in11_6, in11_5, in11_4, in11_3, in11_2, in11_1, in11_0, in10_15, in10_14, in10_13, in10_12, in10_11, in10_10, in10_9, in10_8, in10_7, in10_6, in10_5, in10_4, in10_3, in10_2, in10_1, in10_0, in9_15, in9_14, in9_13, in9_12, in9_11, in9_10, in9_9, in9_8, in9_7, in9_6, in9_5, in9_4, in9_3, in9_2, in9_1, in9_0, in8_15, in8_14, in8_13, in8_12, in8_11, in8_10, in8_9, in8_8, in8_7, in8_6, in8_5, in8_4, in8_3, in8_2, in8_1, in8_0, in7_15, in7_14, in7_13, in7_12, in7_11, in7_10, in7_9, in7_8, in7_7, in7_6, in7_5, in7_4, in7_3, in7_2, in7_1, in7_0, in6_15, in6_14, in6_13, in6_12, in6_11, in6_10, in6_9, in6_8, in6_7, in6_6, in6_5, in6_4, in6_3, in6_2, in6_1, in6_0, in5_15, in5_14, in5_13, in5_12, in5_11, in5_10, in5_9, in5_8, in5_7, in5_6, in5_5, in5_4, in5_3, in5_2, in5_1, in5_0, in4_15, in4_14, in4_13, in4_12, in4_11, in4_10, in4_9, in4_8, in4_7, in4_6, in4_5, in4_4, in4_3, in4_2, in4_1, in4_0, in3_15, in3_14, in3_13, in3_12, in3_11, in3_10, in3_9, in3_8, in3_7, in3_6, in3_5, in3_4, in3_3, in3_2, in3_1, in3_0, in2_15, in2_14, in2_13, in2_12, in2_11, in2_10, in2_9, in2_8, in2_7, in2_6, in2_5, in2_4, in2_3, in2_2, in2_1, in2_0, in1_15, in1_14, in1_13, in1_12, in1_11, in1_10, in1_9, in1_8, in1_7, in1_6, in1_5, in1_4, in1_3, in1_2, in1_1, in1_0, in0_15, in0_14, in0_13, in0_12, in0_11, in0_10, in0_9, in0_8, in0_7, in0_6, in0_5, in0_4, in0_3, in0_2, in0_1, in0_0, out255, out254, out253, out252, out251, out250, out249, out248, out247, out246, out245, out244, out243, out242, out241, out240, out239, out238, out237, out236, out235, out234, out233, out232, out231, out230, out229, out228, out227, out226, out225, out224, out223, out222, out221, out220, out219, out218, out217, out216, out215, out214, out213, out212, out211, out210, out209, out208, out207, out206, out205, out204, out203, out202, out201, out200, out199, out198, out197, out196, out195, out194, out193, out192, out191, out190, out189, out188, out187, out186, out185, out184, out183, out182, out181, out180, out179, out178, out177, out176, out175, out174, out173, out172, out171, out170, out169, out168, out167, out166, out165, out164, out163, out162, out161, out160, out159, out158, out157, out156, out155, out154, out153, out152, out151, out150, out149, out148, out147, out146, out145, out144, out143, out142, out141, out140, out139, out138, out137, out136, out135, out134, out133, out132, out131, out130, out129, out128, out127, out126, out125, out124, out123, out122, out121, out120, out119, out118, out117, out116, out115, out114, out113, out112, out111, out110, out109, out108, out107, out106, out105, out104, out103, out102, out101, out100, out99, out98, out97, out96, out95, out94, out93, out92, out91, out90, out89, out88, out87, out86, out85, out84, out83, out82, out81, out80, out79, out78, out77, out76, out75, out74, out73, out72, out71, out70, out69, out68, out67, out66, out65, out64, out63, out62, out61, out60, out59, out58, out57, out56, out55, out54, out53, out52, out51, out50, out49, out48, out47, out46, out45, out44, out43, out42, out41, out40, out39, out38, out37, out36, out35, out34, out33, out32, out31, out30, out29, out28, out27, out26, out25, out24, out23, out22, out21, out20, out19, out18, out17, out16, out15, out14, out13, out12, out11, out10, out9, out8, out7, out6, out5, out4, out3, out2, out1, out0;
    parameter real vdd = 0.9;
    parameter real vth = 0.45;
    parameter real tr = 20p;
    analog begin
        V(out0) <+ transition((V(in0_0) > vth) ? vdd : 0.0, 0, tr, tr);
        V(out1) <+ transition((V(in0_1) > vth) ? vdd : 0.0, 0, tr, tr);
        V(out2) <+ transition((V(in0_2) > vth) ? vdd : 0.0, 0, tr, tr);
        V(out3) <+ transition((V(in0_3) > vth) ? vdd : 0.0, 0, tr, tr);
        V(out4) <+ transition((V(in0_4) > vth) ? vdd : 0.0, 0, tr, tr);
        V(out5) <+ transition((V(in0_5) > vth) ? vdd : 0.0, 0, tr, tr);
        V(out6) <+ transition((V(in0_6) > vth) ? vdd : 0.0, 0, tr, tr);
        V(out7) <+ transition((V(in0_7) > vth) ? vdd : 0.0, 0, tr, tr);
        V(out8) <+ transition((V(in0_8) > vth) ? vdd : 0.0, 0, tr, tr);
        V(out9) <+ transition((V(in0_9) > vth) ? vdd : 0.0, 0, tr, tr);
        V(out10) <+ transition((V(in0_10) > vth) ? vdd : 0.0, 0, tr, tr);
        V(out11) <+ transition((V(in0_11) > vth) ? vdd : 0.0, 0, tr, tr);
        V(out12) <+ transition((V(in0_12) > vth) ? vdd : 0.0, 0, tr, tr);
        V(out13) <+ transition((V(in0_13) > vth) ? vdd : 0.0, 0, tr, tr);
        V(out14) <+ transition((V(in0_14) > vth) ? vdd : 0.0, 0, tr, tr);
        V(out15) <+ transition((V(in0_15) > vth) ? vdd : 0.0, 0, tr, tr);
        V(out16) <+ transition((V(in1_0) > vth) ? vdd : 0.0, 0, tr, tr);
        V(out17) <+ transition((V(in1_1) > vth) ? vdd : 0.0, 0, tr, tr);
        V(out18) <+ transition((V(in1_2) > vth) ? vdd : 0.0, 0, tr, tr);
        V(out19) <+ transition((V(in1_3) > vth) ? vdd : 0.0, 0, tr, tr);
        V(out20) <+ transition((V(in1_4) > vth) ? vdd : 0.0, 0, tr, tr);
        V(out21) <+ transition((V(in1_5) > vth) ? vdd : 0.0, 0, tr, tr);
        V(out22) <+ transition((V(in1_6) > vth) ? vdd : 0.0, 0, tr, tr);
        V(out23) <+ transition((V(in1_7) > vth) ? vdd : 0.0, 0, tr, tr);
        V(out24) <+ transition((V(in1_8) > vth) ? vdd : 0.0, 0, tr, tr);
        V(out25) <+ transition((V(in1_9) > vth) ? vdd : 0.0, 0, tr, tr);
        V(out26) <+ transition((V(in1_10) > vth) ? vdd : 0.0, 0, tr, tr);
        V(out27) <+ transition((V(in1_11) > vth) ? vdd : 0.0, 0, tr, tr);
        V(out28) <+ transition((V(in1_12) > vth) ? vdd : 0.0, 0, tr, tr);
        V(out29) <+ transition((V(in1_13) > vth) ? vdd : 0.0, 0, tr, tr);
        V(out30) <+ transition((V(in1_14) > vth) ? vdd : 0.0, 0, tr, tr);
        V(out31) <+ transition((V(in1_15) > vth) ? vdd : 0.0, 0, tr, tr);
        V(out32) <+ transition((V(in2_0) > vth) ? vdd : 0.0, 0, tr, tr);
        V(out33) <+ transition((V(in2_1) > vth) ? vdd : 0.0, 0, tr, tr);
        V(out34) <+ transition((V(in2_2) > vth) ? vdd : 0.0, 0, tr, tr);
        V(out35) <+ transition((V(in2_3) > vth) ? vdd : 0.0, 0, tr, tr);
        V(out36) <+ transition((V(in2_4) > vth) ? vdd : 0.0, 0, tr, tr);
        V(out37) <+ transition((V(in2_5) > vth) ? vdd : 0.0, 0, tr, tr);
        V(out38) <+ transition((V(in2_6) > vth) ? vdd : 0.0, 0, tr, tr);
        V(out39) <+ transition((V(in2_7) > vth) ? vdd : 0.0, 0, tr, tr);
        V(out40) <+ transition((V(in2_8) > vth) ? vdd : 0.0, 0, tr, tr);
        V(out41) <+ transition((V(in2_9) > vth) ? vdd : 0.0, 0, tr, tr);
        V(out42) <+ transition((V(in2_10) > vth) ? vdd : 0.0, 0, tr, tr);
        V(out43) <+ transition((V(in2_11) > vth) ? vdd : 0.0, 0, tr, tr);
        V(out44) <+ transition((V(in2_12) > vth) ? vdd : 0.0, 0, tr, tr);
        V(out45) <+ transition((V(in2_13) > vth) ? vdd : 0.0, 0, tr, tr);
        V(out46) <+ transition((V(in2_14) > vth) ? vdd : 0.0, 0, tr, tr);
        V(out47) <+ transition((V(in2_15) > vth) ? vdd : 0.0, 0, tr, tr);
        V(out48) <+ transition((V(in3_0) > vth) ? vdd : 0.0, 0, tr, tr);
        V(out49) <+ transition((V(in3_1) > vth) ? vdd : 0.0, 0, tr, tr);
        V(out50) <+ transition((V(in3_2) > vth) ? vdd : 0.0, 0, tr, tr);
        V(out51) <+ transition((V(in3_3) > vth) ? vdd : 0.0, 0, tr, tr);
        V(out52) <+ transition((V(in3_4) > vth) ? vdd : 0.0, 0, tr, tr);
        V(out53) <+ transition((V(in3_5) > vth) ? vdd : 0.0, 0, tr, tr);
        V(out54) <+ transition((V(in3_6) > vth) ? vdd : 0.0, 0, tr, tr);
        V(out55) <+ transition((V(in3_7) > vth) ? vdd : 0.0, 0, tr, tr);
        V(out56) <+ transition((V(in3_8) > vth) ? vdd : 0.0, 0, tr, tr);
        V(out57) <+ transition((V(in3_9) > vth) ? vdd : 0.0, 0, tr, tr);
        V(out58) <+ transition((V(in3_10) > vth) ? vdd : 0.0, 0, tr, tr);
        V(out59) <+ transition((V(in3_11) > vth) ? vdd : 0.0, 0, tr, tr);
        V(out60) <+ transition((V(in3_12) > vth) ? vdd : 0.0, 0, tr, tr);
        V(out61) <+ transition((V(in3_13) > vth) ? vdd : 0.0, 0, tr, tr);
        V(out62) <+ transition((V(in3_14) > vth) ? vdd : 0.0, 0, tr, tr);
        V(out63) <+ transition((V(in3_15) > vth) ? vdd : 0.0, 0, tr, tr);
        V(out64) <+ transition((V(in4_0) > vth) ? vdd : 0.0, 0, tr, tr);
        V(out65) <+ transition((V(in4_1) > vth) ? vdd : 0.0, 0, tr, tr);
        V(out66) <+ transition((V(in4_2) > vth) ? vdd : 0.0, 0, tr, tr);
        V(out67) <+ transition((V(in4_3) > vth) ? vdd : 0.0, 0, tr, tr);
        V(out68) <+ transition((V(in4_4) > vth) ? vdd : 0.0, 0, tr, tr);
        V(out69) <+ transition((V(in4_5) > vth) ? vdd : 0.0, 0, tr, tr);
        V(out70) <+ transition((V(in4_6) > vth) ? vdd : 0.0, 0, tr, tr);
        V(out71) <+ transition((V(in4_7) > vth) ? vdd : 0.0, 0, tr, tr);
        V(out72) <+ transition((V(in4_8) > vth) ? vdd : 0.0, 0, tr, tr);
        V(out73) <+ transition((V(in4_9) > vth) ? vdd : 0.0, 0, tr, tr);
        V(out74) <+ transition((V(in4_10) > vth) ? vdd : 0.0, 0, tr, tr);
        V(out75) <+ transition((V(in4_11) > vth) ? vdd : 0.0, 0, tr, tr);
        V(out76) <+ transition((V(in4_12) > vth) ? vdd : 0.0, 0, tr, tr);
        V(out77) <+ transition((V(in4_13) > vth) ? vdd : 0.0, 0, tr, tr);
        V(out78) <+ transition((V(in4_14) > vth) ? vdd : 0.0, 0, tr, tr);
        V(out79) <+ transition((V(in4_15) > vth) ? vdd : 0.0, 0, tr, tr);
        V(out80) <+ transition((V(in5_0) > vth) ? vdd : 0.0, 0, tr, tr);
        V(out81) <+ transition((V(in5_1) > vth) ? vdd : 0.0, 0, tr, tr);
        V(out82) <+ transition((V(in5_2) > vth) ? vdd : 0.0, 0, tr, tr);
        V(out83) <+ transition((V(in5_3) > vth) ? vdd : 0.0, 0, tr, tr);
        V(out84) <+ transition((V(in5_4) > vth) ? vdd : 0.0, 0, tr, tr);
        V(out85) <+ transition((V(in5_5) > vth) ? vdd : 0.0, 0, tr, tr);
        V(out86) <+ transition((V(in5_6) > vth) ? vdd : 0.0, 0, tr, tr);
        V(out87) <+ transition((V(in5_7) > vth) ? vdd : 0.0, 0, tr, tr);
        V(out88) <+ transition((V(in5_8) > vth) ? vdd : 0.0, 0, tr, tr);
        V(out89) <+ transition((V(in5_9) > vth) ? vdd : 0.0, 0, tr, tr);
        V(out90) <+ transition((V(in5_10) > vth) ? vdd : 0.0, 0, tr, tr);
        V(out91) <+ transition((V(in5_11) > vth) ? vdd : 0.0, 0, tr, tr);
        V(out92) <+ transition((V(in5_12) > vth) ? vdd : 0.0, 0, tr, tr);
        V(out93) <+ transition((V(in5_13) > vth) ? vdd : 0.0, 0, tr, tr);
        V(out94) <+ transition((V(in5_14) > vth) ? vdd : 0.0, 0, tr, tr);
        V(out95) <+ transition((V(in5_15) > vth) ? vdd : 0.0, 0, tr, tr);
        V(out96) <+ transition((V(in6_0) > vth) ? vdd : 0.0, 0, tr, tr);
        V(out97) <+ transition((V(in6_1) > vth) ? vdd : 0.0, 0, tr, tr);
        V(out98) <+ transition((V(in6_2) > vth) ? vdd : 0.0, 0, tr, tr);
        V(out99) <+ transition((V(in6_3) > vth) ? vdd : 0.0, 0, tr, tr);
        V(out100) <+ transition((V(in6_4) > vth) ? vdd : 0.0, 0, tr, tr);
        V(out101) <+ transition((V(in6_5) > vth) ? vdd : 0.0, 0, tr, tr);
        V(out102) <+ transition((V(in6_6) > vth) ? vdd : 0.0, 0, tr, tr);
        V(out103) <+ transition((V(in6_7) > vth) ? vdd : 0.0, 0, tr, tr);
        V(out104) <+ transition((V(in6_8) > vth) ? vdd : 0.0, 0, tr, tr);
        V(out105) <+ transition((V(in6_9) > vth) ? vdd : 0.0, 0, tr, tr);
        V(out106) <+ transition((V(in6_10) > vth) ? vdd : 0.0, 0, tr, tr);
        V(out107) <+ transition((V(in6_11) > vth) ? vdd : 0.0, 0, tr, tr);
        V(out108) <+ transition((V(in6_12) > vth) ? vdd : 0.0, 0, tr, tr);
        V(out109) <+ transition((V(in6_13) > vth) ? vdd : 0.0, 0, tr, tr);
        V(out110) <+ transition((V(in6_14) > vth) ? vdd : 0.0, 0, tr, tr);
        V(out111) <+ transition((V(in6_15) > vth) ? vdd : 0.0, 0, tr, tr);
        V(out112) <+ transition((V(in7_0) > vth) ? vdd : 0.0, 0, tr, tr);
        V(out113) <+ transition((V(in7_1) > vth) ? vdd : 0.0, 0, tr, tr);
        V(out114) <+ transition((V(in7_2) > vth) ? vdd : 0.0, 0, tr, tr);
        V(out115) <+ transition((V(in7_3) > vth) ? vdd : 0.0, 0, tr, tr);
        V(out116) <+ transition((V(in7_4) > vth) ? vdd : 0.0, 0, tr, tr);
        V(out117) <+ transition((V(in7_5) > vth) ? vdd : 0.0, 0, tr, tr);
        V(out118) <+ transition((V(in7_6) > vth) ? vdd : 0.0, 0, tr, tr);
        V(out119) <+ transition((V(in7_7) > vth) ? vdd : 0.0, 0, tr, tr);
        V(out120) <+ transition((V(in7_8) > vth) ? vdd : 0.0, 0, tr, tr);
        V(out121) <+ transition((V(in7_9) > vth) ? vdd : 0.0, 0, tr, tr);
        V(out122) <+ transition((V(in7_10) > vth) ? vdd : 0.0, 0, tr, tr);
        V(out123) <+ transition((V(in7_11) > vth) ? vdd : 0.0, 0, tr, tr);
        V(out124) <+ transition((V(in7_12) > vth) ? vdd : 0.0, 0, tr, tr);
        V(out125) <+ transition((V(in7_13) > vth) ? vdd : 0.0, 0, tr, tr);
        V(out126) <+ transition((V(in7_14) > vth) ? vdd : 0.0, 0, tr, tr);
        V(out127) <+ transition((V(in7_15) > vth) ? vdd : 0.0, 0, tr, tr);
        V(out128) <+ transition((V(in8_0) > vth) ? vdd : 0.0, 0, tr, tr);
        V(out129) <+ transition((V(in8_1) > vth) ? vdd : 0.0, 0, tr, tr);
        V(out130) <+ transition((V(in8_2) > vth) ? vdd : 0.0, 0, tr, tr);
        V(out131) <+ transition((V(in8_3) > vth) ? vdd : 0.0, 0, tr, tr);
        V(out132) <+ transition((V(in8_4) > vth) ? vdd : 0.0, 0, tr, tr);
        V(out133) <+ transition((V(in8_5) > vth) ? vdd : 0.0, 0, tr, tr);
        V(out134) <+ transition((V(in8_6) > vth) ? vdd : 0.0, 0, tr, tr);
        V(out135) <+ transition((V(in8_7) > vth) ? vdd : 0.0, 0, tr, tr);
        V(out136) <+ transition((V(in8_8) > vth) ? vdd : 0.0, 0, tr, tr);
        V(out137) <+ transition((V(in8_9) > vth) ? vdd : 0.0, 0, tr, tr);
        V(out138) <+ transition((V(in8_10) > vth) ? vdd : 0.0, 0, tr, tr);
        V(out139) <+ transition((V(in8_11) > vth) ? vdd : 0.0, 0, tr, tr);
        V(out140) <+ transition((V(in8_12) > vth) ? vdd : 0.0, 0, tr, tr);
        V(out141) <+ transition((V(in8_13) > vth) ? vdd : 0.0, 0, tr, tr);
        V(out142) <+ transition((V(in8_14) > vth) ? vdd : 0.0, 0, tr, tr);
        V(out143) <+ transition((V(in8_15) > vth) ? vdd : 0.0, 0, tr, tr);
        V(out144) <+ transition((V(in9_0) > vth) ? vdd : 0.0, 0, tr, tr);
        V(out145) <+ transition((V(in9_1) > vth) ? vdd : 0.0, 0, tr, tr);
        V(out146) <+ transition((V(in9_2) > vth) ? vdd : 0.0, 0, tr, tr);
        V(out147) <+ transition((V(in9_3) > vth) ? vdd : 0.0, 0, tr, tr);
        V(out148) <+ transition((V(in9_4) > vth) ? vdd : 0.0, 0, tr, tr);
        V(out149) <+ transition((V(in9_5) > vth) ? vdd : 0.0, 0, tr, tr);
        V(out150) <+ transition((V(in9_6) > vth) ? vdd : 0.0, 0, tr, tr);
        V(out151) <+ transition((V(in9_7) > vth) ? vdd : 0.0, 0, tr, tr);
        V(out152) <+ transition((V(in9_8) > vth) ? vdd : 0.0, 0, tr, tr);
        V(out153) <+ transition((V(in9_9) > vth) ? vdd : 0.0, 0, tr, tr);
        V(out154) <+ transition((V(in9_10) > vth) ? vdd : 0.0, 0, tr, tr);
        V(out155) <+ transition((V(in9_11) > vth) ? vdd : 0.0, 0, tr, tr);
        V(out156) <+ transition((V(in9_12) > vth) ? vdd : 0.0, 0, tr, tr);
        V(out157) <+ transition((V(in9_13) > vth) ? vdd : 0.0, 0, tr, tr);
        V(out158) <+ transition((V(in9_14) > vth) ? vdd : 0.0, 0, tr, tr);
        V(out159) <+ transition((V(in9_15) > vth) ? vdd : 0.0, 0, tr, tr);
        V(out160) <+ transition((V(in10_0) > vth) ? vdd : 0.0, 0, tr, tr);
        V(out161) <+ transition((V(in10_1) > vth) ? vdd : 0.0, 0, tr, tr);
        V(out162) <+ transition((V(in10_2) > vth) ? vdd : 0.0, 0, tr, tr);
        V(out163) <+ transition((V(in10_3) > vth) ? vdd : 0.0, 0, tr, tr);
        V(out164) <+ transition((V(in10_4) > vth) ? vdd : 0.0, 0, tr, tr);
        V(out165) <+ transition((V(in10_5) > vth) ? vdd : 0.0, 0, tr, tr);
        V(out166) <+ transition((V(in10_6) > vth) ? vdd : 0.0, 0, tr, tr);
        V(out167) <+ transition((V(in10_7) > vth) ? vdd : 0.0, 0, tr, tr);
        V(out168) <+ transition((V(in10_8) > vth) ? vdd : 0.0, 0, tr, tr);
        V(out169) <+ transition((V(in10_9) > vth) ? vdd : 0.0, 0, tr, tr);
        V(out170) <+ transition((V(in10_10) > vth) ? vdd : 0.0, 0, tr, tr);
        V(out171) <+ transition((V(in10_11) > vth) ? vdd : 0.0, 0, tr, tr);
        V(out172) <+ transition((V(in10_12) > vth) ? vdd : 0.0, 0, tr, tr);
        V(out173) <+ transition((V(in10_13) > vth) ? vdd : 0.0, 0, tr, tr);
        V(out174) <+ transition((V(in10_14) > vth) ? vdd : 0.0, 0, tr, tr);
        V(out175) <+ transition((V(in10_15) > vth) ? vdd : 0.0, 0, tr, tr);
        V(out176) <+ transition((V(in11_0) > vth) ? vdd : 0.0, 0, tr, tr);
        V(out177) <+ transition((V(in11_1) > vth) ? vdd : 0.0, 0, tr, tr);
        V(out178) <+ transition((V(in11_2) > vth) ? vdd : 0.0, 0, tr, tr);
        V(out179) <+ transition((V(in11_3) > vth) ? vdd : 0.0, 0, tr, tr);
        V(out180) <+ transition((V(in11_4) > vth) ? vdd : 0.0, 0, tr, tr);
        V(out181) <+ transition((V(in11_5) > vth) ? vdd : 0.0, 0, tr, tr);
        V(out182) <+ transition((V(in11_6) > vth) ? vdd : 0.0, 0, tr, tr);
        V(out183) <+ transition((V(in11_7) > vth) ? vdd : 0.0, 0, tr, tr);
        V(out184) <+ transition((V(in11_8) > vth) ? vdd : 0.0, 0, tr, tr);
        V(out185) <+ transition((V(in11_9) > vth) ? vdd : 0.0, 0, tr, tr);
        V(out186) <+ transition((V(in11_10) > vth) ? vdd : 0.0, 0, tr, tr);
        V(out187) <+ transition((V(in11_11) > vth) ? vdd : 0.0, 0, tr, tr);
        V(out188) <+ transition((V(in11_12) > vth) ? vdd : 0.0, 0, tr, tr);
        V(out189) <+ transition((V(in11_13) > vth) ? vdd : 0.0, 0, tr, tr);
        V(out190) <+ transition((V(in11_14) > vth) ? vdd : 0.0, 0, tr, tr);
        V(out191) <+ transition((V(in11_15) > vth) ? vdd : 0.0, 0, tr, tr);
        V(out192) <+ transition((V(in12_0) > vth) ? vdd : 0.0, 0, tr, tr);
        V(out193) <+ transition((V(in12_1) > vth) ? vdd : 0.0, 0, tr, tr);
        V(out194) <+ transition((V(in12_2) > vth) ? vdd : 0.0, 0, tr, tr);
        V(out195) <+ transition((V(in12_3) > vth) ? vdd : 0.0, 0, tr, tr);
        V(out196) <+ transition((V(in12_4) > vth) ? vdd : 0.0, 0, tr, tr);
        V(out197) <+ transition((V(in12_5) > vth) ? vdd : 0.0, 0, tr, tr);
        V(out198) <+ transition((V(in12_6) > vth) ? vdd : 0.0, 0, tr, tr);
        V(out199) <+ transition((V(in12_7) > vth) ? vdd : 0.0, 0, tr, tr);
        V(out200) <+ transition((V(in12_8) > vth) ? vdd : 0.0, 0, tr, tr);
        V(out201) <+ transition((V(in12_9) > vth) ? vdd : 0.0, 0, tr, tr);
        V(out202) <+ transition((V(in12_10) > vth) ? vdd : 0.0, 0, tr, tr);
        V(out203) <+ transition((V(in12_11) > vth) ? vdd : 0.0, 0, tr, tr);
        V(out204) <+ transition((V(in12_12) > vth) ? vdd : 0.0, 0, tr, tr);
        V(out205) <+ transition((V(in12_13) > vth) ? vdd : 0.0, 0, tr, tr);
        V(out206) <+ transition((V(in12_14) > vth) ? vdd : 0.0, 0, tr, tr);
        V(out207) <+ transition((V(in12_15) > vth) ? vdd : 0.0, 0, tr, tr);
        V(out208) <+ transition((V(in13_0) > vth) ? vdd : 0.0, 0, tr, tr);
        V(out209) <+ transition((V(in13_1) > vth) ? vdd : 0.0, 0, tr, tr);
        V(out210) <+ transition((V(in13_2) > vth) ? vdd : 0.0, 0, tr, tr);
        V(out211) <+ transition((V(in13_3) > vth) ? vdd : 0.0, 0, tr, tr);
        V(out212) <+ transition((V(in13_4) > vth) ? vdd : 0.0, 0, tr, tr);
        V(out213) <+ transition((V(in13_5) > vth) ? vdd : 0.0, 0, tr, tr);
        V(out214) <+ transition((V(in13_6) > vth) ? vdd : 0.0, 0, tr, tr);
        V(out215) <+ transition((V(in13_7) > vth) ? vdd : 0.0, 0, tr, tr);
        V(out216) <+ transition((V(in13_8) > vth) ? vdd : 0.0, 0, tr, tr);
        V(out217) <+ transition((V(in13_9) > vth) ? vdd : 0.0, 0, tr, tr);
        V(out218) <+ transition((V(in13_10) > vth) ? vdd : 0.0, 0, tr, tr);
        V(out219) <+ transition((V(in13_11) > vth) ? vdd : 0.0, 0, tr, tr);
        V(out220) <+ transition((V(in13_12) > vth) ? vdd : 0.0, 0, tr, tr);
        V(out221) <+ transition((V(in13_13) > vth) ? vdd : 0.0, 0, tr, tr);
        V(out222) <+ transition((V(in13_14) > vth) ? vdd : 0.0, 0, tr, tr);
        V(out223) <+ transition((V(in13_15) > vth) ? vdd : 0.0, 0, tr, tr);
        V(out224) <+ transition((V(in14_0) > vth) ? vdd : 0.0, 0, tr, tr);
        V(out225) <+ transition((V(in14_1) > vth) ? vdd : 0.0, 0, tr, tr);
        V(out226) <+ transition((V(in14_2) > vth) ? vdd : 0.0, 0, tr, tr);
        V(out227) <+ transition((V(in14_3) > vth) ? vdd : 0.0, 0, tr, tr);
        V(out228) <+ transition((V(in14_4) > vth) ? vdd : 0.0, 0, tr, tr);
        V(out229) <+ transition((V(in14_5) > vth) ? vdd : 0.0, 0, tr, tr);
        V(out230) <+ transition((V(in14_6) > vth) ? vdd : 0.0, 0, tr, tr);
        V(out231) <+ transition((V(in14_7) > vth) ? vdd : 0.0, 0, tr, tr);
        V(out232) <+ transition((V(in14_8) > vth) ? vdd : 0.0, 0, tr, tr);
        V(out233) <+ transition((V(in14_9) > vth) ? vdd : 0.0, 0, tr, tr);
        V(out234) <+ transition((V(in14_10) > vth) ? vdd : 0.0, 0, tr, tr);
        V(out235) <+ transition((V(in14_11) > vth) ? vdd : 0.0, 0, tr, tr);
        V(out236) <+ transition((V(in14_12) > vth) ? vdd : 0.0, 0, tr, tr);
        V(out237) <+ transition((V(in14_13) > vth) ? vdd : 0.0, 0, tr, tr);
        V(out238) <+ transition((V(in14_14) > vth) ? vdd : 0.0, 0, tr, tr);
        V(out239) <+ transition((V(in14_15) > vth) ? vdd : 0.0, 0, tr, tr);
        V(out240) <+ transition((V(in15_0) > vth) ? vdd : 0.0, 0, tr, tr);
        V(out241) <+ transition((V(in15_1) > vth) ? vdd : 0.0, 0, tr, tr);
        V(out242) <+ transition((V(in15_2) > vth) ? vdd : 0.0, 0, tr, tr);
        V(out243) <+ transition((V(in15_3) > vth) ? vdd : 0.0, 0, tr, tr);
        V(out244) <+ transition((V(in15_4) > vth) ? vdd : 0.0, 0, tr, tr);
        V(out245) <+ transition((V(in15_5) > vth) ? vdd : 0.0, 0, tr, tr);
        V(out246) <+ transition((V(in15_6) > vth) ? vdd : 0.0, 0, tr, tr);
        V(out247) <+ transition((V(in15_7) > vth) ? vdd : 0.0, 0, tr, tr);
        V(out248) <+ transition((V(in15_8) > vth) ? vdd : 0.0, 0, tr, tr);
        V(out249) <+ transition((V(in15_9) > vth) ? vdd : 0.0, 0, tr, tr);
        V(out250) <+ transition((V(in15_10) > vth) ? vdd : 0.0, 0, tr, tr);
        V(out251) <+ transition((V(in15_11) > vth) ? vdd : 0.0, 0, tr, tr);
        V(out252) <+ transition((V(in15_12) > vth) ? vdd : 0.0, 0, tr, tr);
        V(out253) <+ transition((V(in15_13) > vth) ? vdd : 0.0, 0, tr, tr);
        V(out254) <+ transition((V(in15_14) > vth) ? vdd : 0.0, 0, tr, tr);
        V(out255) <+ transition((V(in15_15) > vth) ? vdd : 0.0, 0, tr, tr);
    end
endmodule
