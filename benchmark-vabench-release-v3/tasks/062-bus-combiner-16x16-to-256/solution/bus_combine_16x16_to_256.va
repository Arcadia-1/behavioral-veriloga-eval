`include "constants.vams"
`include "disciplines.vams"

module bus_combine_16x16_to_256(
    input electrical [15:0] in15,
    input electrical [15:0] in14,
    input electrical [15:0] in13,
    input electrical [15:0] in12,
    input electrical [15:0] in11,
    input electrical [15:0] in10,
    input electrical [15:0] in9,
    input electrical [15:0] in8,
    input electrical [15:0] in7,
    input electrical [15:0] in6,
    input electrical [15:0] in5,
    input electrical [15:0] in4,
    input electrical [15:0] in3,
    input electrical [15:0] in2,
    input electrical [15:0] in1,
    input electrical [15:0] in0,
    output electrical [255:0] out_bus
);
    parameter real vdd = 0.9;
    parameter real vth = 0.45;
    parameter real tr = 20p;

    genvar bit;

    analog begin
        for (bit = 0; bit < 16; bit = bit + 1) begin
            V(out_bus[0 + bit]) <+ transition((V(in0[bit]) > vth) ? vdd : 0.0, 0, tr, tr);
            V(out_bus[16 + bit]) <+ transition((V(in1[bit]) > vth) ? vdd : 0.0, 0, tr, tr);
            V(out_bus[32 + bit]) <+ transition((V(in2[bit]) > vth) ? vdd : 0.0, 0, tr, tr);
            V(out_bus[48 + bit]) <+ transition((V(in3[bit]) > vth) ? vdd : 0.0, 0, tr, tr);
            V(out_bus[64 + bit]) <+ transition((V(in4[bit]) > vth) ? vdd : 0.0, 0, tr, tr);
            V(out_bus[80 + bit]) <+ transition((V(in5[bit]) > vth) ? vdd : 0.0, 0, tr, tr);
            V(out_bus[96 + bit]) <+ transition((V(in6[bit]) > vth) ? vdd : 0.0, 0, tr, tr);
            V(out_bus[112 + bit]) <+ transition((V(in7[bit]) > vth) ? vdd : 0.0, 0, tr, tr);
            V(out_bus[128 + bit]) <+ transition((V(in8[bit]) > vth) ? vdd : 0.0, 0, tr, tr);
            V(out_bus[144 + bit]) <+ transition((V(in9[bit]) > vth) ? vdd : 0.0, 0, tr, tr);
            V(out_bus[160 + bit]) <+ transition((V(in10[bit]) > vth) ? vdd : 0.0, 0, tr, tr);
            V(out_bus[176 + bit]) <+ transition((V(in11[bit]) > vth) ? vdd : 0.0, 0, tr, tr);
            V(out_bus[192 + bit]) <+ transition((V(in12[bit]) > vth) ? vdd : 0.0, 0, tr, tr);
            V(out_bus[208 + bit]) <+ transition((V(in13[bit]) > vth) ? vdd : 0.0, 0, tr, tr);
            V(out_bus[224 + bit]) <+ transition((V(in14[bit]) > vth) ? vdd : 0.0, 0, tr, tr);
            V(out_bus[240 + bit]) <+ transition((V(in15[bit]) > vth) ? vdd : 0.0, 0, tr, tr);
        end
    end
endmodule
