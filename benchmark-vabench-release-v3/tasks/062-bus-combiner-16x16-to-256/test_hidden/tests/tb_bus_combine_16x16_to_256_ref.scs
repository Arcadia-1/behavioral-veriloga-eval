simulator lang=spectre
global 0

ahdl_include "bus_combine_16x16_to_256.va"

Vin15_15 (in15_15 0) vsource type=pwl wave=[ 0n 0.9 9n 0.9 10n 0.9 19n 0.9 20n 0 29n 0 30n 0.9 39n 0.9 40n 0.9 49n 0.9 50n 0.9 59n 0.9 ]
Vin15_14 (in15_14 0) vsource type=pwl wave=[ 0n 0 9n 0 10n 0.9 19n 0.9 20n 0 29n 0 30n 0 39n 0 40n 0 49n 0 50n 0 59n 0 ]
Vin15_13 (in15_13 0) vsource type=pwl wave=[ 0n 0 9n 0 10n 0 19n 0 20n 0.9 29n 0.9 30n 0 39n 0 40n 0 49n 0 50n 0 59n 0 ]
Vin15_12 (in15_12 0) vsource type=pwl wave=[ 0n 0 9n 0 10n 0 19n 0 20n 0 29n 0 30n 0.9 39n 0.9 40n 0 49n 0 50n 0 59n 0 ]
Vin15_11 (in15_11 0) vsource type=pwl wave=[ 0n 0 9n 0 10n 0 19n 0 20n 0 29n 0 30n 0 39n 0 40n 0 49n 0 50n 0 59n 0 ]
Vin15_10 (in15_10 0) vsource type=pwl wave=[ 0n 0.9 9n 0.9 10n 0 19n 0 20n 0 29n 0 30n 0 39n 0 40n 0.9 49n 0.9 50n 0.9 59n 0.9 ]
Vin15_9 (in15_9 0) vsource type=pwl wave=[ 0n 0 9n 0 10n 0.9 19n 0.9 20n 0 29n 0 30n 0 39n 0 40n 0 49n 0 50n 0 59n 0 ]
Vin15_8 (in15_8 0) vsource type=pwl wave=[ 0n 0 9n 0 10n 0 19n 0 20n 0.9 29n 0.9 30n 0 39n 0 40n 0 49n 0 50n 0 59n 0 ]
Vin15_7 (in15_7 0) vsource type=pwl wave=[ 0n 0 9n 0 10n 0 19n 0 20n 0 29n 0 30n 0.9 39n 0.9 40n 0 49n 0 50n 0 59n 0 ]
Vin15_6 (in15_6 0) vsource type=pwl wave=[ 0n 0 9n 0 10n 0 19n 0 20n 0 29n 0 30n 0 39n 0 40n 0 49n 0 50n 0 59n 0 ]
Vin15_5 (in15_5 0) vsource type=pwl wave=[ 0n 0.9 9n 0.9 10n 0 19n 0 20n 0 29n 0 30n 0 39n 0 40n 0.9 49n 0.9 50n 0.9 59n 0.9 ]
Vin15_4 (in15_4 0) vsource type=pwl wave=[ 0n 0 9n 0 10n 0.9 19n 0.9 20n 0 29n 0 30n 0 39n 0 40n 0 49n 0 50n 0 59n 0 ]
Vin15_3 (in15_3 0) vsource type=pwl wave=[ 0n 0 9n 0 10n 0 19n 0 20n 0.9 29n 0.9 30n 0 39n 0 40n 0 49n 0 50n 0 59n 0 ]
Vin15_2 (in15_2 0) vsource type=pwl wave=[ 0n 0 9n 0 10n 0 19n 0 20n 0 29n 0 30n 0.9 39n 0.9 40n 0 49n 0 50n 0 59n 0 ]
Vin15_1 (in15_1 0) vsource type=pwl wave=[ 0n 0 9n 0 10n 0 19n 0 20n 0 29n 0 30n 0 39n 0 40n 0 49n 0 50n 0 59n 0 ]
Vin15_0 (in15_0 0) vsource type=pwl wave=[ 0n 0.9 9n 0.9 10n 0 19n 0 20n 0 29n 0 30n 0 39n 0 40n 0.9 49n 0.9 50n 0.9 59n 0.9 ]
Vin14_15 (in14_15 0) vsource type=pwl wave=[ 0n 0 9n 0 10n 0.9 19n 0.9 20n 0 29n 0 30n 0 39n 0 40n 0 49n 0 50n 0 59n 0 ]
Vin14_14 (in14_14 0) vsource type=pwl wave=[ 0n 0 9n 0 10n 0 19n 0 20n 0.9 29n 0.9 30n 0 39n 0 40n 0 49n 0 50n 0 59n 0 ]
Vin14_13 (in14_13 0) vsource type=pwl wave=[ 0n 0 9n 0 10n 0 19n 0 20n 0 29n 0 30n 0.9 39n 0.9 40n 0 49n 0 50n 0 59n 0 ]
Vin14_12 (in14_12 0) vsource type=pwl wave=[ 0n 0 9n 0 10n 0 19n 0 20n 0 29n 0 30n 0 39n 0 40n 0 49n 0 50n 0 59n 0 ]
Vin14_11 (in14_11 0) vsource type=pwl wave=[ 0n 0.9 9n 0.9 10n 0 19n 0 20n 0 29n 0 30n 0 39n 0 40n 0.9 49n 0.9 50n 0.9 59n 0.9 ]
Vin14_10 (in14_10 0) vsource type=pwl wave=[ 0n 0 9n 0 10n 0.9 19n 0.9 20n 0 29n 0 30n 0 39n 0 40n 0 49n 0 50n 0 59n 0 ]
Vin14_9 (in14_9 0) vsource type=pwl wave=[ 0n 0 9n 0 10n 0 19n 0 20n 0.9 29n 0.9 30n 0 39n 0 40n 0 49n 0 50n 0 59n 0 ]
Vin14_8 (in14_8 0) vsource type=pwl wave=[ 0n 0 9n 0 10n 0 19n 0 20n 0 29n 0 30n 0.9 39n 0.9 40n 0 49n 0 50n 0 59n 0 ]
Vin14_7 (in14_7 0) vsource type=pwl wave=[ 0n 0 9n 0 10n 0 19n 0 20n 0 29n 0 30n 0 39n 0 40n 0 49n 0 50n 0 59n 0 ]
Vin14_6 (in14_6 0) vsource type=pwl wave=[ 0n 0.9 9n 0.9 10n 0 19n 0 20n 0 29n 0 30n 0 39n 0 40n 0.9 49n 0.9 50n 0.9 59n 0.9 ]
Vin14_5 (in14_5 0) vsource type=pwl wave=[ 0n 0 9n 0 10n 0.9 19n 0.9 20n 0 29n 0 30n 0 39n 0 40n 0 49n 0 50n 0 59n 0 ]
Vin14_4 (in14_4 0) vsource type=pwl wave=[ 0n 0 9n 0 10n 0 19n 0 20n 0.9 29n 0.9 30n 0 39n 0 40n 0 49n 0 50n 0 59n 0 ]
Vin14_3 (in14_3 0) vsource type=pwl wave=[ 0n 0 9n 0 10n 0 19n 0 20n 0 29n 0 30n 0.9 39n 0.9 40n 0 49n 0 50n 0 59n 0 ]
Vin14_2 (in14_2 0) vsource type=pwl wave=[ 0n 0 9n 0 10n 0 19n 0 20n 0 29n 0 30n 0 39n 0 40n 0 49n 0 50n 0 59n 0 ]
Vin14_1 (in14_1 0) vsource type=pwl wave=[ 0n 0.9 9n 0.9 10n 0 19n 0 20n 0 29n 0 30n 0 39n 0 40n 0.9 49n 0.9 50n 0.9 59n 0.9 ]
Vin14_0 (in14_0 0) vsource type=pwl wave=[ 0n 0 9n 0 10n 0.9 19n 0.9 20n 0 29n 0 30n 0 39n 0 40n 0 49n 0 50n 0 59n 0 ]
Vin13_15 (in13_15 0) vsource type=pwl wave=[ 0n 0 9n 0 10n 0 19n 0 20n 0.9 29n 0.9 30n 0 39n 0 40n 0 49n 0 50n 0 59n 0 ]
Vin13_14 (in13_14 0) vsource type=pwl wave=[ 0n 0 9n 0 10n 0 19n 0 20n 0 29n 0 30n 0.9 39n 0.9 40n 0 49n 0 50n 0 59n 0 ]
Vin13_13 (in13_13 0) vsource type=pwl wave=[ 0n 0 9n 0 10n 0 19n 0 20n 0 29n 0 30n 0 39n 0 40n 0 49n 0 50n 0 59n 0 ]
Vin13_12 (in13_12 0) vsource type=pwl wave=[ 0n 0.9 9n 0.9 10n 0 19n 0 20n 0 29n 0 30n 0 39n 0 40n 0.9 49n 0.9 50n 0.9 59n 0.9 ]
Vin13_11 (in13_11 0) vsource type=pwl wave=[ 0n 0 9n 0 10n 0.9 19n 0.9 20n 0 29n 0 30n 0 39n 0 40n 0 49n 0 50n 0 59n 0 ]
Vin13_10 (in13_10 0) vsource type=pwl wave=[ 0n 0 9n 0 10n 0 19n 0 20n 0.9 29n 0.9 30n 0 39n 0 40n 0 49n 0 50n 0 59n 0 ]
Vin13_9 (in13_9 0) vsource type=pwl wave=[ 0n 0 9n 0 10n 0 19n 0 20n 0 29n 0 30n 0.9 39n 0.9 40n 0 49n 0 50n 0 59n 0 ]
Vin13_8 (in13_8 0) vsource type=pwl wave=[ 0n 0 9n 0 10n 0 19n 0 20n 0 29n 0 30n 0 39n 0 40n 0 49n 0 50n 0 59n 0 ]
Vin13_7 (in13_7 0) vsource type=pwl wave=[ 0n 0.9 9n 0.9 10n 0 19n 0 20n 0 29n 0 30n 0 39n 0 40n 0.9 49n 0.9 50n 0.9 59n 0.9 ]
Vin13_6 (in13_6 0) vsource type=pwl wave=[ 0n 0 9n 0 10n 0.9 19n 0.9 20n 0 29n 0 30n 0 39n 0 40n 0 49n 0 50n 0 59n 0 ]
Vin13_5 (in13_5 0) vsource type=pwl wave=[ 0n 0 9n 0 10n 0 19n 0 20n 0.9 29n 0.9 30n 0 39n 0 40n 0 49n 0 50n 0 59n 0 ]
Vin13_4 (in13_4 0) vsource type=pwl wave=[ 0n 0 9n 0 10n 0 19n 0 20n 0 29n 0 30n 0.9 39n 0.9 40n 0 49n 0 50n 0 59n 0 ]
Vin13_3 (in13_3 0) vsource type=pwl wave=[ 0n 0 9n 0 10n 0 19n 0 20n 0 29n 0 30n 0 39n 0 40n 0 49n 0 50n 0 59n 0 ]
Vin13_2 (in13_2 0) vsource type=pwl wave=[ 0n 0.9 9n 0.9 10n 0 19n 0 20n 0 29n 0 30n 0 39n 0 40n 0.9 49n 0.9 50n 0.9 59n 0.9 ]
Vin13_1 (in13_1 0) vsource type=pwl wave=[ 0n 0 9n 0 10n 0.9 19n 0.9 20n 0 29n 0 30n 0 39n 0 40n 0 49n 0 50n 0 59n 0 ]
Vin13_0 (in13_0 0) vsource type=pwl wave=[ 0n 0 9n 0 10n 0 19n 0 20n 0.9 29n 0.9 30n 0 39n 0 40n 0 49n 0 50n 0 59n 0 ]
Vin12_15 (in12_15 0) vsource type=pwl wave=[ 0n 0 9n 0 10n 0 19n 0 20n 0 29n 0 30n 0.9 39n 0.9 40n 0 49n 0 50n 0 59n 0 ]
Vin12_14 (in12_14 0) vsource type=pwl wave=[ 0n 0 9n 0 10n 0 19n 0 20n 0 29n 0 30n 0 39n 0 40n 0 49n 0 50n 0 59n 0 ]
Vin12_13 (in12_13 0) vsource type=pwl wave=[ 0n 0.9 9n 0.9 10n 0 19n 0 20n 0 29n 0 30n 0 39n 0 40n 0.9 49n 0.9 50n 0.9 59n 0.9 ]
Vin12_12 (in12_12 0) vsource type=pwl wave=[ 0n 0 9n 0 10n 0.9 19n 0.9 20n 0 29n 0 30n 0 39n 0 40n 0 49n 0 50n 0 59n 0 ]
Vin12_11 (in12_11 0) vsource type=pwl wave=[ 0n 0 9n 0 10n 0 19n 0 20n 0.9 29n 0.9 30n 0 39n 0 40n 0 49n 0 50n 0 59n 0 ]
Vin12_10 (in12_10 0) vsource type=pwl wave=[ 0n 0 9n 0 10n 0 19n 0 20n 0 29n 0 30n 0.9 39n 0.9 40n 0 49n 0 50n 0 59n 0 ]
Vin12_9 (in12_9 0) vsource type=pwl wave=[ 0n 0 9n 0 10n 0 19n 0 20n 0 29n 0 30n 0 39n 0 40n 0 49n 0 50n 0 59n 0 ]
Vin12_8 (in12_8 0) vsource type=pwl wave=[ 0n 0.9 9n 0.9 10n 0 19n 0 20n 0 29n 0 30n 0 39n 0 40n 0.9 49n 0.9 50n 0.9 59n 0.9 ]
Vin12_7 (in12_7 0) vsource type=pwl wave=[ 0n 0 9n 0 10n 0.9 19n 0.9 20n 0 29n 0 30n 0 39n 0 40n 0 49n 0 50n 0 59n 0 ]
Vin12_6 (in12_6 0) vsource type=pwl wave=[ 0n 0 9n 0 10n 0 19n 0 20n 0.9 29n 0.9 30n 0 39n 0 40n 0 49n 0 50n 0 59n 0 ]
Vin12_5 (in12_5 0) vsource type=pwl wave=[ 0n 0 9n 0 10n 0 19n 0 20n 0 29n 0 30n 0.9 39n 0.9 40n 0 49n 0 50n 0 59n 0 ]
Vin12_4 (in12_4 0) vsource type=pwl wave=[ 0n 0 9n 0 10n 0 19n 0 20n 0 29n 0 30n 0 39n 0 40n 0 49n 0 50n 0 59n 0 ]
Vin12_3 (in12_3 0) vsource type=pwl wave=[ 0n 0.9 9n 0.9 10n 0 19n 0 20n 0 29n 0 30n 0 39n 0 40n 0.9 49n 0.9 50n 0.9 59n 0.9 ]
Vin12_2 (in12_2 0) vsource type=pwl wave=[ 0n 0 9n 0 10n 0.9 19n 0.9 20n 0 29n 0 30n 0 39n 0 40n 0 49n 0 50n 0 59n 0 ]
Vin12_1 (in12_1 0) vsource type=pwl wave=[ 0n 0 9n 0 10n 0 19n 0 20n 0.9 29n 0.9 30n 0 39n 0 40n 0 49n 0 50n 0 59n 0 ]
Vin12_0 (in12_0 0) vsource type=pwl wave=[ 0n 0 9n 0 10n 0 19n 0 20n 0 29n 0 30n 0.9 39n 0.9 40n 0 49n 0 50n 0 59n 0 ]
Vin11_15 (in11_15 0) vsource type=pwl wave=[ 0n 0 9n 0 10n 0 19n 0 20n 0 29n 0 30n 0 39n 0 40n 0 49n 0 50n 0 59n 0 ]
Vin11_14 (in11_14 0) vsource type=pwl wave=[ 0n 0.9 9n 0.9 10n 0 19n 0 20n 0 29n 0 30n 0 39n 0 40n 0.9 49n 0.9 50n 0.9 59n 0.9 ]
Vin11_13 (in11_13 0) vsource type=pwl wave=[ 0n 0 9n 0 10n 0.9 19n 0.9 20n 0 29n 0 30n 0 39n 0 40n 0 49n 0 50n 0 59n 0 ]
Vin11_12 (in11_12 0) vsource type=pwl wave=[ 0n 0 9n 0 10n 0 19n 0 20n 0.9 29n 0.9 30n 0 39n 0 40n 0 49n 0 50n 0 59n 0 ]
Vin11_11 (in11_11 0) vsource type=pwl wave=[ 0n 0 9n 0 10n 0 19n 0 20n 0 29n 0 30n 0.9 39n 0.9 40n 0 49n 0 50n 0 59n 0 ]
Vin11_10 (in11_10 0) vsource type=pwl wave=[ 0n 0 9n 0 10n 0 19n 0 20n 0 29n 0 30n 0 39n 0 40n 0 49n 0 50n 0 59n 0 ]
Vin11_9 (in11_9 0) vsource type=pwl wave=[ 0n 0.9 9n 0.9 10n 0 19n 0 20n 0 29n 0 30n 0 39n 0 40n 0.9 49n 0.9 50n 0.9 59n 0.9 ]
Vin11_8 (in11_8 0) vsource type=pwl wave=[ 0n 0 9n 0 10n 0.9 19n 0.9 20n 0 29n 0 30n 0 39n 0 40n 0 49n 0 50n 0 59n 0 ]
Vin11_7 (in11_7 0) vsource type=pwl wave=[ 0n 0 9n 0 10n 0 19n 0 20n 0.9 29n 0.9 30n 0 39n 0 40n 0 49n 0 50n 0 59n 0 ]
Vin11_6 (in11_6 0) vsource type=pwl wave=[ 0n 0 9n 0 10n 0 19n 0 20n 0 29n 0 30n 0.9 39n 0.9 40n 0 49n 0 50n 0 59n 0 ]
Vin11_5 (in11_5 0) vsource type=pwl wave=[ 0n 0 9n 0 10n 0 19n 0 20n 0 29n 0 30n 0 39n 0 40n 0 49n 0 50n 0 59n 0 ]
Vin11_4 (in11_4 0) vsource type=pwl wave=[ 0n 0.9 9n 0.9 10n 0 19n 0 20n 0 29n 0 30n 0 39n 0 40n 0.9 49n 0.9 50n 0.9 59n 0.9 ]
Vin11_3 (in11_3 0) vsource type=pwl wave=[ 0n 0 9n 0 10n 0.9 19n 0.9 20n 0 29n 0 30n 0 39n 0 40n 0 49n 0 50n 0 59n 0 ]
Vin11_2 (in11_2 0) vsource type=pwl wave=[ 0n 0 9n 0 10n 0 19n 0 20n 0.9 29n 0.9 30n 0 39n 0 40n 0 49n 0 50n 0 59n 0 ]
Vin11_1 (in11_1 0) vsource type=pwl wave=[ 0n 0 9n 0 10n 0 19n 0 20n 0 29n 0 30n 0.9 39n 0.9 40n 0 49n 0 50n 0 59n 0 ]
Vin11_0 (in11_0 0) vsource type=pwl wave=[ 0n 0 9n 0 10n 0 19n 0 20n 0 29n 0 30n 0 39n 0 40n 0 49n 0 50n 0 59n 0 ]
Vin10_15 (in10_15 0) vsource type=pwl wave=[ 0n 0.9 9n 0.9 10n 0 19n 0 20n 0 29n 0 30n 0 39n 0 40n 0.9 49n 0.9 50n 0.9 59n 0.9 ]
Vin10_14 (in10_14 0) vsource type=pwl wave=[ 0n 0 9n 0 10n 0.9 19n 0.9 20n 0 29n 0 30n 0 39n 0 40n 0 49n 0 50n 0 59n 0 ]
Vin10_13 (in10_13 0) vsource type=pwl wave=[ 0n 0 9n 0 10n 0 19n 0 20n 0.9 29n 0.9 30n 0 39n 0 40n 0 49n 0 50n 0 59n 0 ]
Vin10_12 (in10_12 0) vsource type=pwl wave=[ 0n 0 9n 0 10n 0 19n 0 20n 0 29n 0 30n 0.9 39n 0.9 40n 0 49n 0 50n 0 59n 0 ]
Vin10_11 (in10_11 0) vsource type=pwl wave=[ 0n 0 9n 0 10n 0 19n 0 20n 0 29n 0 30n 0 39n 0 40n 0 49n 0 50n 0 59n 0 ]
Vin10_10 (in10_10 0) vsource type=pwl wave=[ 0n 0.9 9n 0.9 10n 0 19n 0 20n 0 29n 0 30n 0 39n 0 40n 0.9 49n 0.9 50n 0.9 59n 0.9 ]
Vin10_9 (in10_9 0) vsource type=pwl wave=[ 0n 0 9n 0 10n 0.9 19n 0.9 20n 0 29n 0 30n 0 39n 0 40n 0 49n 0 50n 0 59n 0 ]
Vin10_8 (in10_8 0) vsource type=pwl wave=[ 0n 0 9n 0 10n 0 19n 0 20n 0.9 29n 0.9 30n 0 39n 0 40n 0 49n 0 50n 0 59n 0 ]
Vin10_7 (in10_7 0) vsource type=pwl wave=[ 0n 0 9n 0 10n 0 19n 0 20n 0 29n 0 30n 0.9 39n 0.9 40n 0 49n 0 50n 0 59n 0 ]
Vin10_6 (in10_6 0) vsource type=pwl wave=[ 0n 0 9n 0 10n 0 19n 0 20n 0 29n 0 30n 0 39n 0 40n 0 49n 0 50n 0 59n 0 ]
Vin10_5 (in10_5 0) vsource type=pwl wave=[ 0n 0.9 9n 0.9 10n 0 19n 0 20n 0 29n 0 30n 0 39n 0 40n 0.9 49n 0.9 50n 0.9 59n 0.9 ]
Vin10_4 (in10_4 0) vsource type=pwl wave=[ 0n 0 9n 0 10n 0.9 19n 0.9 20n 0 29n 0 30n 0 39n 0 40n 0 49n 0 50n 0 59n 0 ]
Vin10_3 (in10_3 0) vsource type=pwl wave=[ 0n 0 9n 0 10n 0 19n 0 20n 0.9 29n 0.9 30n 0 39n 0 40n 0 49n 0 50n 0 59n 0 ]
Vin10_2 (in10_2 0) vsource type=pwl wave=[ 0n 0 9n 0 10n 0 19n 0 20n 0 29n 0 30n 0.9 39n 0.9 40n 0 49n 0 50n 0 59n 0 ]
Vin10_1 (in10_1 0) vsource type=pwl wave=[ 0n 0 9n 0 10n 0 19n 0 20n 0 29n 0 30n 0 39n 0 40n 0 49n 0 50n 0 59n 0 ]
Vin10_0 (in10_0 0) vsource type=pwl wave=[ 0n 0.9 9n 0.9 10n 0 19n 0 20n 0 29n 0 30n 0 39n 0 40n 0.9 49n 0.9 50n 0.9 59n 0.9 ]
Vin9_15 (in9_15 0) vsource type=pwl wave=[ 0n 0 9n 0 10n 0.9 19n 0.9 20n 0 29n 0 30n 0 39n 0 40n 0 49n 0 50n 0 59n 0 ]
Vin9_14 (in9_14 0) vsource type=pwl wave=[ 0n 0 9n 0 10n 0 19n 0 20n 0.9 29n 0.9 30n 0 39n 0 40n 0 49n 0 50n 0 59n 0 ]
Vin9_13 (in9_13 0) vsource type=pwl wave=[ 0n 0 9n 0 10n 0 19n 0 20n 0 29n 0 30n 0.9 39n 0.9 40n 0 49n 0 50n 0 59n 0 ]
Vin9_12 (in9_12 0) vsource type=pwl wave=[ 0n 0 9n 0 10n 0 19n 0 20n 0 29n 0 30n 0 39n 0 40n 0 49n 0 50n 0 59n 0 ]
Vin9_11 (in9_11 0) vsource type=pwl wave=[ 0n 0.9 9n 0.9 10n 0 19n 0 20n 0 29n 0 30n 0 39n 0 40n 0.9 49n 0.9 50n 0.9 59n 0.9 ]
Vin9_10 (in9_10 0) vsource type=pwl wave=[ 0n 0 9n 0 10n 0.9 19n 0.9 20n 0 29n 0 30n 0 39n 0 40n 0 49n 0 50n 0 59n 0 ]
Vin9_9 (in9_9 0) vsource type=pwl wave=[ 0n 0 9n 0 10n 0 19n 0 20n 0.9 29n 0.9 30n 0 39n 0 40n 0 49n 0 50n 0 59n 0 ]
Vin9_8 (in9_8 0) vsource type=pwl wave=[ 0n 0 9n 0 10n 0 19n 0 20n 0 29n 0 30n 0.9 39n 0.9 40n 0 49n 0 50n 0 59n 0 ]
Vin9_7 (in9_7 0) vsource type=pwl wave=[ 0n 0 9n 0 10n 0 19n 0 20n 0 29n 0 30n 0 39n 0 40n 0 49n 0 50n 0 59n 0 ]
Vin9_6 (in9_6 0) vsource type=pwl wave=[ 0n 0.9 9n 0.9 10n 0 19n 0 20n 0 29n 0 30n 0 39n 0 40n 0.9 49n 0.9 50n 0.9 59n 0.9 ]
Vin9_5 (in9_5 0) vsource type=pwl wave=[ 0n 0 9n 0 10n 0.9 19n 0.9 20n 0 29n 0 30n 0 39n 0 40n 0 49n 0 50n 0 59n 0 ]
Vin9_4 (in9_4 0) vsource type=pwl wave=[ 0n 0 9n 0 10n 0 19n 0 20n 0.9 29n 0.9 30n 0 39n 0 40n 0 49n 0 50n 0 59n 0 ]
Vin9_3 (in9_3 0) vsource type=pwl wave=[ 0n 0 9n 0 10n 0 19n 0 20n 0 29n 0 30n 0.9 39n 0.9 40n 0 49n 0 50n 0 59n 0 ]
Vin9_2 (in9_2 0) vsource type=pwl wave=[ 0n 0 9n 0 10n 0 19n 0 20n 0 29n 0 30n 0 39n 0 40n 0 49n 0 50n 0 59n 0 ]
Vin9_1 (in9_1 0) vsource type=pwl wave=[ 0n 0.9 9n 0.9 10n 0 19n 0 20n 0 29n 0 30n 0 39n 0 40n 0.9 49n 0.9 50n 0.9 59n 0.9 ]
Vin9_0 (in9_0 0) vsource type=pwl wave=[ 0n 0 9n 0 10n 0.9 19n 0.9 20n 0 29n 0 30n 0 39n 0 40n 0 49n 0 50n 0 59n 0 ]
Vin8_15 (in8_15 0) vsource type=pwl wave=[ 0n 0 9n 0 10n 0 19n 0 20n 0.9 29n 0.9 30n 0 39n 0 40n 0 49n 0 50n 0 59n 0 ]
Vin8_14 (in8_14 0) vsource type=pwl wave=[ 0n 0 9n 0 10n 0 19n 0 20n 0 29n 0 30n 0.9 39n 0.9 40n 0 49n 0 50n 0 59n 0 ]
Vin8_13 (in8_13 0) vsource type=pwl wave=[ 0n 0 9n 0 10n 0 19n 0 20n 0 29n 0 30n 0 39n 0 40n 0 49n 0 50n 0 59n 0 ]
Vin8_12 (in8_12 0) vsource type=pwl wave=[ 0n 0.9 9n 0.9 10n 0 19n 0 20n 0 29n 0 30n 0 39n 0 40n 0.9 49n 0.9 50n 0.9 59n 0.9 ]
Vin8_11 (in8_11 0) vsource type=pwl wave=[ 0n 0 9n 0 10n 0.9 19n 0.9 20n 0 29n 0 30n 0 39n 0 40n 0 49n 0 50n 0 59n 0 ]
Vin8_10 (in8_10 0) vsource type=pwl wave=[ 0n 0 9n 0 10n 0 19n 0 20n 0.9 29n 0.9 30n 0 39n 0 40n 0 49n 0 50n 0 59n 0 ]
Vin8_9 (in8_9 0) vsource type=pwl wave=[ 0n 0 9n 0 10n 0 19n 0 20n 0 29n 0 30n 0.9 39n 0.9 40n 0 49n 0 50n 0 59n 0 ]
Vin8_8 (in8_8 0) vsource type=pwl wave=[ 0n 0 9n 0 10n 0 19n 0 20n 0 29n 0 30n 0 39n 0 40n 0 49n 0 50n 0 59n 0 ]
Vin8_7 (in8_7 0) vsource type=pwl wave=[ 0n 0.9 9n 0.9 10n 0 19n 0 20n 0 29n 0 30n 0 39n 0 40n 0.9 49n 0.9 50n 0.9 59n 0.9 ]
Vin8_6 (in8_6 0) vsource type=pwl wave=[ 0n 0 9n 0 10n 0.9 19n 0.9 20n 0 29n 0 30n 0 39n 0 40n 0 49n 0 50n 0 59n 0 ]
Vin8_5 (in8_5 0) vsource type=pwl wave=[ 0n 0 9n 0 10n 0 19n 0 20n 0.9 29n 0.9 30n 0 39n 0 40n 0 49n 0 50n 0 59n 0 ]
Vin8_4 (in8_4 0) vsource type=pwl wave=[ 0n 0 9n 0 10n 0 19n 0 20n 0 29n 0 30n 0.9 39n 0.9 40n 0 49n 0 50n 0 59n 0 ]
Vin8_3 (in8_3 0) vsource type=pwl wave=[ 0n 0 9n 0 10n 0 19n 0 20n 0 29n 0 30n 0 39n 0 40n 0 49n 0 50n 0 59n 0 ]
Vin8_2 (in8_2 0) vsource type=pwl wave=[ 0n 0.9 9n 0.9 10n 0 19n 0 20n 0 29n 0 30n 0 39n 0 40n 0.9 49n 0.9 50n 0.9 59n 0.9 ]
Vin8_1 (in8_1 0) vsource type=pwl wave=[ 0n 0 9n 0 10n 0.9 19n 0.9 20n 0 29n 0 30n 0 39n 0 40n 0 49n 0 50n 0 59n 0 ]
Vin8_0 (in8_0 0) vsource type=pwl wave=[ 0n 0 9n 0 10n 0.9 19n 0.9 20n 0.9 29n 0.9 30n 0.9 39n 0.9 40n 0 49n 0 50n 0.9 59n 0.9 ]
Vin7_15 (in7_15 0) vsource type=pwl wave=[ 0n 0 9n 0 10n 0.9 19n 0.9 20n 0 29n 0 30n 0.9 39n 0.9 40n 0 49n 0 50n 0.9 59n 0.9 ]
Vin7_14 (in7_14 0) vsource type=pwl wave=[ 0n 0 9n 0 10n 0 19n 0 20n 0 29n 0 30n 0 39n 0 40n 0 49n 0 50n 0 59n 0 ]
Vin7_13 (in7_13 0) vsource type=pwl wave=[ 0n 0.9 9n 0.9 10n 0 19n 0 20n 0 29n 0 30n 0 39n 0 40n 0.9 49n 0.9 50n 0.9 59n 0.9 ]
Vin7_12 (in7_12 0) vsource type=pwl wave=[ 0n 0 9n 0 10n 0.9 19n 0.9 20n 0 29n 0 30n 0 39n 0 40n 0 49n 0 50n 0 59n 0 ]
Vin7_11 (in7_11 0) vsource type=pwl wave=[ 0n 0 9n 0 10n 0 19n 0 20n 0.9 29n 0.9 30n 0 39n 0 40n 0 49n 0 50n 0 59n 0 ]
Vin7_10 (in7_10 0) vsource type=pwl wave=[ 0n 0 9n 0 10n 0 19n 0 20n 0 29n 0 30n 0.9 39n 0.9 40n 0 49n 0 50n 0 59n 0 ]
Vin7_9 (in7_9 0) vsource type=pwl wave=[ 0n 0 9n 0 10n 0 19n 0 20n 0 29n 0 30n 0 39n 0 40n 0 49n 0 50n 0 59n 0 ]
Vin7_8 (in7_8 0) vsource type=pwl wave=[ 0n 0.9 9n 0.9 10n 0 19n 0 20n 0 29n 0 30n 0 39n 0 40n 0.9 49n 0.9 50n 0.9 59n 0.9 ]
Vin7_7 (in7_7 0) vsource type=pwl wave=[ 0n 0 9n 0 10n 0.9 19n 0.9 20n 0 29n 0 30n 0 39n 0 40n 0 49n 0 50n 0 59n 0 ]
Vin7_6 (in7_6 0) vsource type=pwl wave=[ 0n 0 9n 0 10n 0 19n 0 20n 0.9 29n 0.9 30n 0 39n 0 40n 0 49n 0 50n 0 59n 0 ]
Vin7_5 (in7_5 0) vsource type=pwl wave=[ 0n 0 9n 0 10n 0 19n 0 20n 0 29n 0 30n 0.9 39n 0.9 40n 0 49n 0 50n 0 59n 0 ]
Vin7_4 (in7_4 0) vsource type=pwl wave=[ 0n 0 9n 0 10n 0 19n 0 20n 0 29n 0 30n 0 39n 0 40n 0 49n 0 50n 0 59n 0 ]
Vin7_3 (in7_3 0) vsource type=pwl wave=[ 0n 0.9 9n 0.9 10n 0 19n 0 20n 0 29n 0 30n 0 39n 0 40n 0.9 49n 0.9 50n 0.9 59n 0.9 ]
Vin7_2 (in7_2 0) vsource type=pwl wave=[ 0n 0 9n 0 10n 0.9 19n 0.9 20n 0 29n 0 30n 0 39n 0 40n 0 49n 0 50n 0 59n 0 ]
Vin7_1 (in7_1 0) vsource type=pwl wave=[ 0n 0 9n 0 10n 0 19n 0 20n 0.9 29n 0.9 30n 0 39n 0 40n 0 49n 0 50n 0 59n 0 ]
Vin7_0 (in7_0 0) vsource type=pwl wave=[ 0n 0 9n 0 10n 0 19n 0 20n 0 29n 0 30n 0.9 39n 0.9 40n 0 49n 0 50n 0 59n 0 ]
Vin6_15 (in6_15 0) vsource type=pwl wave=[ 0n 0 9n 0 10n 0 19n 0 20n 0 29n 0 30n 0 39n 0 40n 0 49n 0 50n 0 59n 0 ]
Vin6_14 (in6_14 0) vsource type=pwl wave=[ 0n 0.9 9n 0.9 10n 0 19n 0 20n 0 29n 0 30n 0 39n 0 40n 0.9 49n 0.9 50n 0.9 59n 0.9 ]
Vin6_13 (in6_13 0) vsource type=pwl wave=[ 0n 0 9n 0 10n 0.9 19n 0.9 20n 0 29n 0 30n 0 39n 0 40n 0 49n 0 50n 0 59n 0 ]
Vin6_12 (in6_12 0) vsource type=pwl wave=[ 0n 0 9n 0 10n 0 19n 0 20n 0.9 29n 0.9 30n 0 39n 0 40n 0 49n 0 50n 0 59n 0 ]
Vin6_11 (in6_11 0) vsource type=pwl wave=[ 0n 0 9n 0 10n 0 19n 0 20n 0 29n 0 30n 0.9 39n 0.9 40n 0 49n 0 50n 0 59n 0 ]
Vin6_10 (in6_10 0) vsource type=pwl wave=[ 0n 0 9n 0 10n 0 19n 0 20n 0 29n 0 30n 0 39n 0 40n 0 49n 0 50n 0 59n 0 ]
Vin6_9 (in6_9 0) vsource type=pwl wave=[ 0n 0.9 9n 0.9 10n 0 19n 0 20n 0 29n 0 30n 0 39n 0 40n 0.9 49n 0.9 50n 0.9 59n 0.9 ]
Vin6_8 (in6_8 0) vsource type=pwl wave=[ 0n 0 9n 0 10n 0.9 19n 0.9 20n 0 29n 0 30n 0 39n 0 40n 0 49n 0 50n 0 59n 0 ]
Vin6_7 (in6_7 0) vsource type=pwl wave=[ 0n 0 9n 0 10n 0 19n 0 20n 0.9 29n 0.9 30n 0 39n 0 40n 0 49n 0 50n 0 59n 0 ]
Vin6_6 (in6_6 0) vsource type=pwl wave=[ 0n 0 9n 0 10n 0 19n 0 20n 0 29n 0 30n 0.9 39n 0.9 40n 0 49n 0 50n 0 59n 0 ]
Vin6_5 (in6_5 0) vsource type=pwl wave=[ 0n 0 9n 0 10n 0 19n 0 20n 0 29n 0 30n 0 39n 0 40n 0 49n 0 50n 0 59n 0 ]
Vin6_4 (in6_4 0) vsource type=pwl wave=[ 0n 0.9 9n 0.9 10n 0 19n 0 20n 0 29n 0 30n 0 39n 0 40n 0.9 49n 0.9 50n 0.9 59n 0.9 ]
Vin6_3 (in6_3 0) vsource type=pwl wave=[ 0n 0 9n 0 10n 0.9 19n 0.9 20n 0 29n 0 30n 0 39n 0 40n 0 49n 0 50n 0 59n 0 ]
Vin6_2 (in6_2 0) vsource type=pwl wave=[ 0n 0 9n 0 10n 0 19n 0 20n 0.9 29n 0.9 30n 0 39n 0 40n 0 49n 0 50n 0 59n 0 ]
Vin6_1 (in6_1 0) vsource type=pwl wave=[ 0n 0 9n 0 10n 0 19n 0 20n 0 29n 0 30n 0.9 39n 0.9 40n 0 49n 0 50n 0 59n 0 ]
Vin6_0 (in6_0 0) vsource type=pwl wave=[ 0n 0 9n 0 10n 0 19n 0 20n 0 29n 0 30n 0 39n 0 40n 0 49n 0 50n 0 59n 0 ]
Vin5_15 (in5_15 0) vsource type=pwl wave=[ 0n 0.9 9n 0.9 10n 0 19n 0 20n 0 29n 0 30n 0 39n 0 40n 0.9 49n 0.9 50n 0.9 59n 0.9 ]
Vin5_14 (in5_14 0) vsource type=pwl wave=[ 0n 0 9n 0 10n 0.9 19n 0.9 20n 0 29n 0 30n 0 39n 0 40n 0 49n 0 50n 0 59n 0 ]
Vin5_13 (in5_13 0) vsource type=pwl wave=[ 0n 0 9n 0 10n 0 19n 0 20n 0.9 29n 0.9 30n 0 39n 0 40n 0 49n 0 50n 0 59n 0 ]
Vin5_12 (in5_12 0) vsource type=pwl wave=[ 0n 0 9n 0 10n 0 19n 0 20n 0 29n 0 30n 0.9 39n 0.9 40n 0 49n 0 50n 0 59n 0 ]
Vin5_11 (in5_11 0) vsource type=pwl wave=[ 0n 0 9n 0 10n 0 19n 0 20n 0 29n 0 30n 0 39n 0 40n 0 49n 0 50n 0 59n 0 ]
Vin5_10 (in5_10 0) vsource type=pwl wave=[ 0n 0.9 9n 0.9 10n 0 19n 0 20n 0 29n 0 30n 0 39n 0 40n 0.9 49n 0.9 50n 0.9 59n 0.9 ]
Vin5_9 (in5_9 0) vsource type=pwl wave=[ 0n 0 9n 0 10n 0.9 19n 0.9 20n 0 29n 0 30n 0 39n 0 40n 0 49n 0 50n 0 59n 0 ]
Vin5_8 (in5_8 0) vsource type=pwl wave=[ 0n 0 9n 0 10n 0 19n 0 20n 0.9 29n 0.9 30n 0 39n 0 40n 0 49n 0 50n 0 59n 0 ]
Vin5_7 (in5_7 0) vsource type=pwl wave=[ 0n 0 9n 0 10n 0 19n 0 20n 0 29n 0 30n 0.9 39n 0.9 40n 0 49n 0 50n 0 59n 0 ]
Vin5_6 (in5_6 0) vsource type=pwl wave=[ 0n 0 9n 0 10n 0 19n 0 20n 0 29n 0 30n 0 39n 0 40n 0 49n 0 50n 0 59n 0 ]
Vin5_5 (in5_5 0) vsource type=pwl wave=[ 0n 0.9 9n 0.9 10n 0 19n 0 20n 0 29n 0 30n 0 39n 0 40n 0.9 49n 0.9 50n 0.9 59n 0.9 ]
Vin5_4 (in5_4 0) vsource type=pwl wave=[ 0n 0 9n 0 10n 0.9 19n 0.9 20n 0 29n 0 30n 0 39n 0 40n 0 49n 0 50n 0 59n 0 ]
Vin5_3 (in5_3 0) vsource type=pwl wave=[ 0n 0 9n 0 10n 0 19n 0 20n 0.9 29n 0.9 30n 0 39n 0 40n 0 49n 0 50n 0 59n 0 ]
Vin5_2 (in5_2 0) vsource type=pwl wave=[ 0n 0 9n 0 10n 0 19n 0 20n 0 29n 0 30n 0.9 39n 0.9 40n 0 49n 0 50n 0 59n 0 ]
Vin5_1 (in5_1 0) vsource type=pwl wave=[ 0n 0 9n 0 10n 0 19n 0 20n 0 29n 0 30n 0 39n 0 40n 0 49n 0 50n 0 59n 0 ]
Vin5_0 (in5_0 0) vsource type=pwl wave=[ 0n 0.9 9n 0.9 10n 0 19n 0 20n 0 29n 0 30n 0 39n 0 40n 0.9 49n 0.9 50n 0.9 59n 0.9 ]
Vin4_15 (in4_15 0) vsource type=pwl wave=[ 0n 0 9n 0 10n 0.9 19n 0.9 20n 0 29n 0 30n 0 39n 0 40n 0 49n 0 50n 0 59n 0 ]
Vin4_14 (in4_14 0) vsource type=pwl wave=[ 0n 0 9n 0 10n 0 19n 0 20n 0.9 29n 0.9 30n 0 39n 0 40n 0 49n 0 50n 0 59n 0 ]
Vin4_13 (in4_13 0) vsource type=pwl wave=[ 0n 0 9n 0 10n 0 19n 0 20n 0 29n 0 30n 0.9 39n 0.9 40n 0 49n 0 50n 0 59n 0 ]
Vin4_12 (in4_12 0) vsource type=pwl wave=[ 0n 0 9n 0 10n 0 19n 0 20n 0 29n 0 30n 0 39n 0 40n 0 49n 0 50n 0 59n 0 ]
Vin4_11 (in4_11 0) vsource type=pwl wave=[ 0n 0.9 9n 0.9 10n 0 19n 0 20n 0 29n 0 30n 0 39n 0 40n 0.9 49n 0.9 50n 0.9 59n 0.9 ]
Vin4_10 (in4_10 0) vsource type=pwl wave=[ 0n 0 9n 0 10n 0.9 19n 0.9 20n 0 29n 0 30n 0 39n 0 40n 0 49n 0 50n 0 59n 0 ]
Vin4_9 (in4_9 0) vsource type=pwl wave=[ 0n 0 9n 0 10n 0 19n 0 20n 0.9 29n 0.9 30n 0 39n 0 40n 0 49n 0 50n 0 59n 0 ]
Vin4_8 (in4_8 0) vsource type=pwl wave=[ 0n 0 9n 0 10n 0 19n 0 20n 0 29n 0 30n 0.9 39n 0.9 40n 0 49n 0 50n 0 59n 0 ]
Vin4_7 (in4_7 0) vsource type=pwl wave=[ 0n 0 9n 0 10n 0 19n 0 20n 0 29n 0 30n 0 39n 0 40n 0 49n 0 50n 0 59n 0 ]
Vin4_6 (in4_6 0) vsource type=pwl wave=[ 0n 0.9 9n 0.9 10n 0 19n 0 20n 0 29n 0 30n 0 39n 0 40n 0.9 49n 0.9 50n 0.9 59n 0.9 ]
Vin4_5 (in4_5 0) vsource type=pwl wave=[ 0n 0 9n 0 10n 0.9 19n 0.9 20n 0 29n 0 30n 0 39n 0 40n 0 49n 0 50n 0 59n 0 ]
Vin4_4 (in4_4 0) vsource type=pwl wave=[ 0n 0 9n 0 10n 0 19n 0 20n 0.9 29n 0.9 30n 0 39n 0 40n 0 49n 0 50n 0 59n 0 ]
Vin4_3 (in4_3 0) vsource type=pwl wave=[ 0n 0 9n 0 10n 0 19n 0 20n 0 29n 0 30n 0.9 39n 0.9 40n 0 49n 0 50n 0 59n 0 ]
Vin4_2 (in4_2 0) vsource type=pwl wave=[ 0n 0 9n 0 10n 0 19n 0 20n 0 29n 0 30n 0 39n 0 40n 0 49n 0 50n 0 59n 0 ]
Vin4_1 (in4_1 0) vsource type=pwl wave=[ 0n 0.9 9n 0.9 10n 0 19n 0 20n 0 29n 0 30n 0 39n 0 40n 0.9 49n 0.9 50n 0.9 59n 0.9 ]
Vin4_0 (in4_0 0) vsource type=pwl wave=[ 0n 0 9n 0 10n 0.9 19n 0.9 20n 0 29n 0 30n 0 39n 0 40n 0 49n 0 50n 0 59n 0 ]
Vin3_15 (in3_15 0) vsource type=pwl wave=[ 0n 0 9n 0 10n 0 19n 0 20n 0.9 29n 0.9 30n 0 39n 0 40n 0 49n 0 50n 0 59n 0 ]
Vin3_14 (in3_14 0) vsource type=pwl wave=[ 0n 0 9n 0 10n 0 19n 0 20n 0 29n 0 30n 0.9 39n 0.9 40n 0 49n 0 50n 0 59n 0 ]
Vin3_13 (in3_13 0) vsource type=pwl wave=[ 0n 0 9n 0 10n 0 19n 0 20n 0 29n 0 30n 0 39n 0 40n 0 49n 0 50n 0 59n 0 ]
Vin3_12 (in3_12 0) vsource type=pwl wave=[ 0n 0.9 9n 0.9 10n 0 19n 0 20n 0 29n 0 30n 0 39n 0 40n 0.9 49n 0.9 50n 0.9 59n 0.9 ]
Vin3_11 (in3_11 0) vsource type=pwl wave=[ 0n 0 9n 0 10n 0.9 19n 0.9 20n 0 29n 0 30n 0 39n 0 40n 0 49n 0 50n 0 59n 0 ]
Vin3_10 (in3_10 0) vsource type=pwl wave=[ 0n 0 9n 0 10n 0 19n 0 20n 0.9 29n 0.9 30n 0 39n 0 40n 0 49n 0 50n 0 59n 0 ]
Vin3_9 (in3_9 0) vsource type=pwl wave=[ 0n 0 9n 0 10n 0 19n 0 20n 0 29n 0 30n 0.9 39n 0.9 40n 0 49n 0 50n 0 59n 0 ]
Vin3_8 (in3_8 0) vsource type=pwl wave=[ 0n 0 9n 0 10n 0 19n 0 20n 0 29n 0 30n 0 39n 0 40n 0 49n 0 50n 0 59n 0 ]
Vin3_7 (in3_7 0) vsource type=pwl wave=[ 0n 0.9 9n 0.9 10n 0 19n 0 20n 0 29n 0 30n 0 39n 0 40n 0.9 49n 0.9 50n 0.9 59n 0.9 ]
Vin3_6 (in3_6 0) vsource type=pwl wave=[ 0n 0 9n 0 10n 0.9 19n 0.9 20n 0 29n 0 30n 0 39n 0 40n 0 49n 0 50n 0 59n 0 ]
Vin3_5 (in3_5 0) vsource type=pwl wave=[ 0n 0 9n 0 10n 0 19n 0 20n 0.9 29n 0.9 30n 0 39n 0 40n 0 49n 0 50n 0 59n 0 ]
Vin3_4 (in3_4 0) vsource type=pwl wave=[ 0n 0 9n 0 10n 0 19n 0 20n 0 29n 0 30n 0.9 39n 0.9 40n 0 49n 0 50n 0 59n 0 ]
Vin3_3 (in3_3 0) vsource type=pwl wave=[ 0n 0 9n 0 10n 0 19n 0 20n 0 29n 0 30n 0 39n 0 40n 0 49n 0 50n 0 59n 0 ]
Vin3_2 (in3_2 0) vsource type=pwl wave=[ 0n 0.9 9n 0.9 10n 0 19n 0 20n 0 29n 0 30n 0 39n 0 40n 0.9 49n 0.9 50n 0.9 59n 0.9 ]
Vin3_1 (in3_1 0) vsource type=pwl wave=[ 0n 0 9n 0 10n 0.9 19n 0.9 20n 0 29n 0 30n 0 39n 0 40n 0 49n 0 50n 0 59n 0 ]
Vin3_0 (in3_0 0) vsource type=pwl wave=[ 0n 0 9n 0 10n 0 19n 0 20n 0.9 29n 0.9 30n 0 39n 0 40n 0 49n 0 50n 0 59n 0 ]
Vin2_15 (in2_15 0) vsource type=pwl wave=[ 0n 0 9n 0 10n 0 19n 0 20n 0 29n 0 30n 0.9 39n 0.9 40n 0 49n 0 50n 0 59n 0 ]
Vin2_14 (in2_14 0) vsource type=pwl wave=[ 0n 0 9n 0 10n 0 19n 0 20n 0 29n 0 30n 0 39n 0 40n 0 49n 0 50n 0 59n 0 ]
Vin2_13 (in2_13 0) vsource type=pwl wave=[ 0n 0.9 9n 0.9 10n 0 19n 0 20n 0 29n 0 30n 0 39n 0 40n 0.9 49n 0.9 50n 0.9 59n 0.9 ]
Vin2_12 (in2_12 0) vsource type=pwl wave=[ 0n 0 9n 0 10n 0.9 19n 0.9 20n 0 29n 0 30n 0 39n 0 40n 0 49n 0 50n 0 59n 0 ]
Vin2_11 (in2_11 0) vsource type=pwl wave=[ 0n 0 9n 0 10n 0 19n 0 20n 0.9 29n 0.9 30n 0 39n 0 40n 0 49n 0 50n 0 59n 0 ]
Vin2_10 (in2_10 0) vsource type=pwl wave=[ 0n 0 9n 0 10n 0 19n 0 20n 0 29n 0 30n 0.9 39n 0.9 40n 0 49n 0 50n 0 59n 0 ]
Vin2_9 (in2_9 0) vsource type=pwl wave=[ 0n 0 9n 0 10n 0 19n 0 20n 0 29n 0 30n 0 39n 0 40n 0 49n 0 50n 0 59n 0 ]
Vin2_8 (in2_8 0) vsource type=pwl wave=[ 0n 0.9 9n 0.9 10n 0 19n 0 20n 0 29n 0 30n 0 39n 0 40n 0.9 49n 0.9 50n 0.9 59n 0.9 ]
Vin2_7 (in2_7 0) vsource type=pwl wave=[ 0n 0 9n 0 10n 0.9 19n 0.9 20n 0 29n 0 30n 0 39n 0 40n 0 49n 0 50n 0 59n 0 ]
Vin2_6 (in2_6 0) vsource type=pwl wave=[ 0n 0 9n 0 10n 0 19n 0 20n 0.9 29n 0.9 30n 0 39n 0 40n 0 49n 0 50n 0 59n 0 ]
Vin2_5 (in2_5 0) vsource type=pwl wave=[ 0n 0 9n 0 10n 0 19n 0 20n 0 29n 0 30n 0.9 39n 0.9 40n 0 49n 0 50n 0 59n 0 ]
Vin2_4 (in2_4 0) vsource type=pwl wave=[ 0n 0 9n 0 10n 0 19n 0 20n 0 29n 0 30n 0 39n 0 40n 0 49n 0 50n 0 59n 0 ]
Vin2_3 (in2_3 0) vsource type=pwl wave=[ 0n 0.9 9n 0.9 10n 0 19n 0 20n 0 29n 0 30n 0 39n 0 40n 0.9 49n 0.9 50n 0.9 59n 0.9 ]
Vin2_2 (in2_2 0) vsource type=pwl wave=[ 0n 0 9n 0 10n 0.9 19n 0.9 20n 0 29n 0 30n 0 39n 0 40n 0 49n 0 50n 0 59n 0 ]
Vin2_1 (in2_1 0) vsource type=pwl wave=[ 0n 0 9n 0 10n 0 19n 0 20n 0.9 29n 0.9 30n 0 39n 0 40n 0 49n 0 50n 0 59n 0 ]
Vin2_0 (in2_0 0) vsource type=pwl wave=[ 0n 0 9n 0 10n 0 19n 0 20n 0 29n 0 30n 0.9 39n 0.9 40n 0 49n 0 50n 0 59n 0 ]
Vin1_15 (in1_15 0) vsource type=pwl wave=[ 0n 0 9n 0 10n 0 19n 0 20n 0 29n 0 30n 0 39n 0 40n 0 49n 0 50n 0 59n 0 ]
Vin1_14 (in1_14 0) vsource type=pwl wave=[ 0n 0.9 9n 0.9 10n 0 19n 0 20n 0 29n 0 30n 0 39n 0 40n 0.9 49n 0.9 50n 0.9 59n 0.9 ]
Vin1_13 (in1_13 0) vsource type=pwl wave=[ 0n 0 9n 0 10n 0.9 19n 0.9 20n 0 29n 0 30n 0 39n 0 40n 0 49n 0 50n 0 59n 0 ]
Vin1_12 (in1_12 0) vsource type=pwl wave=[ 0n 0 9n 0 10n 0 19n 0 20n 0.9 29n 0.9 30n 0 39n 0 40n 0 49n 0 50n 0 59n 0 ]
Vin1_11 (in1_11 0) vsource type=pwl wave=[ 0n 0 9n 0 10n 0 19n 0 20n 0 29n 0 30n 0.9 39n 0.9 40n 0 49n 0 50n 0 59n 0 ]
Vin1_10 (in1_10 0) vsource type=pwl wave=[ 0n 0 9n 0 10n 0 19n 0 20n 0 29n 0 30n 0 39n 0 40n 0 49n 0 50n 0 59n 0 ]
Vin1_9 (in1_9 0) vsource type=pwl wave=[ 0n 0.9 9n 0.9 10n 0 19n 0 20n 0 29n 0 30n 0 39n 0 40n 0.9 49n 0.9 50n 0.9 59n 0.9 ]
Vin1_8 (in1_8 0) vsource type=pwl wave=[ 0n 0 9n 0 10n 0.9 19n 0.9 20n 0 29n 0 30n 0 39n 0 40n 0 49n 0 50n 0 59n 0 ]
Vin1_7 (in1_7 0) vsource type=pwl wave=[ 0n 0 9n 0 10n 0 19n 0 20n 0.9 29n 0.9 30n 0 39n 0 40n 0 49n 0 50n 0 59n 0 ]
Vin1_6 (in1_6 0) vsource type=pwl wave=[ 0n 0 9n 0 10n 0 19n 0 20n 0 29n 0 30n 0.9 39n 0.9 40n 0 49n 0 50n 0 59n 0 ]
Vin1_5 (in1_5 0) vsource type=pwl wave=[ 0n 0 9n 0 10n 0 19n 0 20n 0 29n 0 30n 0 39n 0 40n 0 49n 0 50n 0 59n 0 ]
Vin1_4 (in1_4 0) vsource type=pwl wave=[ 0n 0.9 9n 0.9 10n 0 19n 0 20n 0 29n 0 30n 0 39n 0 40n 0.9 49n 0.9 50n 0.9 59n 0.9 ]
Vin1_3 (in1_3 0) vsource type=pwl wave=[ 0n 0 9n 0 10n 0.9 19n 0.9 20n 0 29n 0 30n 0 39n 0 40n 0 49n 0 50n 0 59n 0 ]
Vin1_2 (in1_2 0) vsource type=pwl wave=[ 0n 0 9n 0 10n 0 19n 0 20n 0.9 29n 0.9 30n 0 39n 0 40n 0 49n 0 50n 0 59n 0 ]
Vin1_1 (in1_1 0) vsource type=pwl wave=[ 0n 0 9n 0 10n 0 19n 0 20n 0 29n 0 30n 0.9 39n 0.9 40n 0 49n 0 50n 0 59n 0 ]
Vin1_0 (in1_0 0) vsource type=pwl wave=[ 0n 0 9n 0 10n 0 19n 0 20n 0 29n 0 30n 0 39n 0 40n 0 49n 0 50n 0 59n 0 ]
Vin0_15 (in0_15 0) vsource type=pwl wave=[ 0n 0.9 9n 0.9 10n 0 19n 0 20n 0 29n 0 30n 0 39n 0 40n 0.9 49n 0.9 50n 0.9 59n 0.9 ]
Vin0_14 (in0_14 0) vsource type=pwl wave=[ 0n 0 9n 0 10n 0.9 19n 0.9 20n 0 29n 0 30n 0 39n 0 40n 0 49n 0 50n 0 59n 0 ]
Vin0_13 (in0_13 0) vsource type=pwl wave=[ 0n 0 9n 0 10n 0 19n 0 20n 0.9 29n 0.9 30n 0 39n 0 40n 0 49n 0 50n 0 59n 0 ]
Vin0_12 (in0_12 0) vsource type=pwl wave=[ 0n 0 9n 0 10n 0 19n 0 20n 0 29n 0 30n 0.9 39n 0.9 40n 0 49n 0 50n 0 59n 0 ]
Vin0_11 (in0_11 0) vsource type=pwl wave=[ 0n 0 9n 0 10n 0 19n 0 20n 0 29n 0 30n 0 39n 0 40n 0 49n 0 50n 0 59n 0 ]
Vin0_10 (in0_10 0) vsource type=pwl wave=[ 0n 0.9 9n 0.9 10n 0 19n 0 20n 0 29n 0 30n 0 39n 0 40n 0.9 49n 0.9 50n 0.9 59n 0.9 ]
Vin0_9 (in0_9 0) vsource type=pwl wave=[ 0n 0 9n 0 10n 0.9 19n 0.9 20n 0 29n 0 30n 0 39n 0 40n 0 49n 0 50n 0 59n 0 ]
Vin0_8 (in0_8 0) vsource type=pwl wave=[ 0n 0 9n 0 10n 0 19n 0 20n 0.9 29n 0.9 30n 0 39n 0 40n 0 49n 0 50n 0 59n 0 ]
Vin0_7 (in0_7 0) vsource type=pwl wave=[ 0n 0 9n 0 10n 0 19n 0 20n 0 29n 0 30n 0.9 39n 0.9 40n 0 49n 0 50n 0 59n 0 ]
Vin0_6 (in0_6 0) vsource type=pwl wave=[ 0n 0 9n 0 10n 0 19n 0 20n 0 29n 0 30n 0 39n 0 40n 0 49n 0 50n 0 59n 0 ]
Vin0_5 (in0_5 0) vsource type=pwl wave=[ 0n 0.9 9n 0.9 10n 0 19n 0 20n 0 29n 0 30n 0 39n 0 40n 0.9 49n 0.9 50n 0.9 59n 0.9 ]
Vin0_4 (in0_4 0) vsource type=pwl wave=[ 0n 0 9n 0 10n 0.9 19n 0.9 20n 0 29n 0 30n 0 39n 0 40n 0 49n 0 50n 0 59n 0 ]
Vin0_3 (in0_3 0) vsource type=pwl wave=[ 0n 0 9n 0 10n 0 19n 0 20n 0.9 29n 0.9 30n 0 39n 0 40n 0 49n 0 50n 0 59n 0 ]
Vin0_2 (in0_2 0) vsource type=pwl wave=[ 0n 0 9n 0 10n 0 19n 0 20n 0 29n 0 30n 0.9 39n 0.9 40n 0 49n 0 50n 0 59n 0 ]
Vin0_1 (in0_1 0) vsource type=pwl wave=[ 0n 0 9n 0 10n 0.9 19n 0.9 20n 0 29n 0 30n 0.9 39n 0.9 40n 0 49n 0 50n 0.9 59n 0.9 ]
Vin0_0 (in0_0 0) vsource type=pwl wave=[ 0n 0.9 9n 0.9 10n 0.9 19n 0.9 20n 0 29n 0 30n 0.9 39n 0.9 40n 0.9 49n 0.9 50n 0.9 59n 0.9 ]

XDUT (in15_15 in15_14 in15_13 in15_12 in15_11 in15_10 in15_9 in15_8 in15_7 in15_6 in15_5 in15_4 in15_3 in15_2 in15_1 in15_0 in14_15 in14_14 in14_13 in14_12 in14_11 in14_10 in14_9 in14_8 in14_7 in14_6 in14_5 in14_4 in14_3 in14_2 in14_1 in14_0 in13_15 in13_14 in13_13 in13_12 in13_11 in13_10 in13_9 in13_8 in13_7 in13_6 in13_5 in13_4 in13_3 in13_2 in13_1 in13_0 in12_15 in12_14 in12_13 in12_12 in12_11 in12_10 in12_9 in12_8 in12_7 in12_6 in12_5 in12_4 in12_3 in12_2 in12_1 in12_0 in11_15 in11_14 in11_13 in11_12 in11_11 in11_10 in11_9 in11_8 in11_7 in11_6 in11_5 in11_4 in11_3 in11_2 in11_1 in11_0 in10_15 in10_14 in10_13 in10_12 in10_11 in10_10 in10_9 in10_8 in10_7 in10_6 in10_5 in10_4 in10_3 in10_2 in10_1 in10_0 in9_15 in9_14 in9_13 in9_12 in9_11 in9_10 in9_9 in9_8 in9_7 in9_6 in9_5 in9_4 in9_3 in9_2 in9_1 in9_0 in8_15 in8_14 in8_13 in8_12 in8_11 in8_10 in8_9 in8_8 in8_7 in8_6 in8_5 in8_4 in8_3 in8_2 in8_1 in8_0 in7_15 in7_14 in7_13 in7_12 in7_11 in7_10 in7_9 in7_8 in7_7 in7_6 in7_5 in7_4 in7_3 in7_2 in7_1 in7_0 in6_15 in6_14 in6_13 in6_12 in6_11 in6_10 in6_9 in6_8 in6_7 in6_6 in6_5 in6_4 in6_3 in6_2 in6_1 in6_0 in5_15 in5_14 in5_13 in5_12 in5_11 in5_10 in5_9 in5_8 in5_7 in5_6 in5_5 in5_4 in5_3 in5_2 in5_1 in5_0 in4_15 in4_14 in4_13 in4_12 in4_11 in4_10 in4_9 in4_8 in4_7 in4_6 in4_5 in4_4 in4_3 in4_2 in4_1 in4_0 in3_15 in3_14 in3_13 in3_12 in3_11 in3_10 in3_9 in3_8 in3_7 in3_6 in3_5 in3_4 in3_3 in3_2 in3_1 in3_0 in2_15 in2_14 in2_13 in2_12 in2_11 in2_10 in2_9 in2_8 in2_7 in2_6 in2_5 in2_4 in2_3 in2_2 in2_1 in2_0 in1_15 in1_14 in1_13 in1_12 in1_11 in1_10 in1_9 in1_8 in1_7 in1_6 in1_5 in1_4 in1_3 in1_2 in1_1 in1_0 in0_15 in0_14 in0_13 in0_12 in0_11 in0_10 in0_9 in0_8 in0_7 in0_6 in0_5 in0_4 in0_3 in0_2 in0_1 in0_0 out255 out254 out253 out252 out251 out250 out249 out248 out247 out246 out245 out244 out243 out242 out241 out240 out239 out238 out237 out236 out235 out234 out233 out232 out231 out230 out229 out228 out227 out226 out225 out224 out223 out222 out221 out220 out219 out218 out217 out216 out215 out214 out213 out212 out211 out210 out209 out208 out207 out206 out205 out204 out203 out202 out201 out200 out199 out198 out197 out196 out195 out194 out193 out192 out191 out190 out189 out188 out187 out186 out185 out184 out183 out182 out181 out180 out179 out178 out177 out176 out175 out174 out173 out172 out171 out170 out169 out168 out167 out166 out165 out164 out163 out162 out161 out160 out159 out158 out157 out156 out155 out154 out153 out152 out151 out150 out149 out148 out147 out146 out145 out144 out143 out142 out141 out140 out139 out138 out137 out136 out135 out134 out133 out132 out131 out130 out129 out128 out127 out126 out125 out124 out123 out122 out121 out120 out119 out118 out117 out116 out115 out114 out113 out112 out111 out110 out109 out108 out107 out106 out105 out104 out103 out102 out101 out100 out99 out98 out97 out96 out95 out94 out93 out92 out91 out90 out89 out88 out87 out86 out85 out84 out83 out82 out81 out80 out79 out78 out77 out76 out75 out74 out73 out72 out71 out70 out69 out68 out67 out66 out65 out64 out63 out62 out61 out60 out59 out58 out57 out56 out55 out54 out53 out52 out51 out50 out49 out48 out47 out46 out45 out44 out43 out42 out41 out40 out39 out38 out37 out36 out35 out34 out33 out32 out31 out30 out29 out28 out27 out26 out25 out24 out23 out22 out21 out20 out19 out18 out17 out16 out15 out14 out13 out12 out11 out10 out9 out8 out7 out6 out5 out4 out3 out2 out1 out0) bus_combine_16x16_to_256

tran tran stop=60n maxstep=200p
save in15_15 in15_14 in15_13 in15_12 in15_11 in15_10 in15_9 in15_8 in15_7 in15_6 in15_5 in15_4 in15_3 in15_2 in15_1 in15_0 in14_15 in14_14 in14_13 in14_12 in14_11 in14_10 in14_9 in14_8 in14_7 in14_6 in14_5 in14_4 in14_3 in14_2 in14_1 in14_0 in13_15 in13_14 in13_13 in13_12 in13_11 in13_10 in13_9 in13_8 in13_7 in13_6 in13_5 in13_4 in13_3 in13_2 in13_1 in13_0 in12_15 in12_14 in12_13 in12_12 in12_11 in12_10 in12_9 in12_8 in12_7 in12_6 in12_5 in12_4 in12_3 in12_2 in12_1 in12_0 in11_15 in11_14 in11_13 in11_12 in11_11 in11_10 in11_9 in11_8 in11_7 in11_6 in11_5 in11_4 in11_3 in11_2 in11_1 in11_0 in10_15 in10_14 in10_13 in10_12 in10_11 in10_10 in10_9 in10_8 in10_7 in10_6 in10_5 in10_4 in10_3 in10_2 in10_1 in10_0 in9_15 in9_14 in9_13 in9_12 in9_11 in9_10 in9_9 in9_8 in9_7 in9_6 in9_5 in9_4 in9_3 in9_2 in9_1 in9_0 in8_15 in8_14 in8_13 in8_12 in8_11 in8_10 in8_9 in8_8 in8_7 in8_6 in8_5 in8_4 in8_3 in8_2 in8_1 in8_0 in7_15 in7_14 in7_13 in7_12 in7_11 in7_10 in7_9 in7_8 in7_7 in7_6 in7_5 in7_4 in7_3 in7_2 in7_1 in7_0 in6_15 in6_14 in6_13 in6_12 in6_11 in6_10 in6_9 in6_8 in6_7 in6_6 in6_5 in6_4 in6_3 in6_2 in6_1 in6_0 in5_15 in5_14 in5_13 in5_12 in5_11 in5_10 in5_9 in5_8 in5_7 in5_6 in5_5 in5_4 in5_3 in5_2 in5_1 in5_0 in4_15 in4_14 in4_13 in4_12 in4_11 in4_10 in4_9 in4_8 in4_7 in4_6 in4_5 in4_4 in4_3 in4_2 in4_1 in4_0 in3_15 in3_14 in3_13 in3_12 in3_11 in3_10 in3_9 in3_8 in3_7 in3_6 in3_5 in3_4 in3_3 in3_2 in3_1 in3_0 in2_15 in2_14 in2_13 in2_12 in2_11 in2_10 in2_9 in2_8 in2_7 in2_6 in2_5 in2_4 in2_3 in2_2 in2_1 in2_0 in1_15 in1_14 in1_13 in1_12 in1_11 in1_10 in1_9 in1_8 in1_7 in1_6 in1_5 in1_4 in1_3 in1_2 in1_1 in1_0 in0_15 in0_14 in0_13 in0_12 in0_11 in0_10 in0_9 in0_8 in0_7 in0_6 in0_5 in0_4 in0_3 in0_2 in0_1 in0_0 out255 out254 out253 out252 out251 out250 out249 out248 out247 out246 out245 out244 out243 out242 out241 out240 out239 out238 out237 out236 out235 out234 out233 out232 out231 out230 out229 out228 out227 out226 out225 out224 out223 out222 out221 out220 out219 out218 out217 out216 out215 out214 out213 out212 out211 out210 out209 out208 out207 out206 out205 out204 out203 out202 out201 out200 out199 out198 out197 out196 out195 out194 out193 out192 out191 out190 out189 out188 out187 out186 out185 out184 out183 out182 out181 out180 out179 out178 out177 out176 out175 out174 out173 out172 out171 out170 out169 out168 out167 out166 out165 out164 out163 out162 out161 out160 out159 out158 out157 out156 out155 out154 out153 out152 out151 out150 out149 out148 out147 out146 out145 out144 out143 out142 out141 out140 out139 out138 out137 out136 out135 out134 out133 out132 out131 out130 out129 out128 out127 out126 out125 out124 out123 out122 out121 out120 out119 out118 out117 out116 out115 out114 out113 out112 out111 out110 out109 out108 out107 out106 out105 out104 out103 out102 out101 out100 out99 out98 out97 out96 out95 out94 out93 out92 out91 out90 out89 out88 out87 out86 out85 out84 out83 out82 out81 out80 out79 out78 out77 out76 out75 out74 out73 out72 out71 out70 out69 out68 out67 out66 out65 out64 out63 out62 out61 out60 out59 out58 out57 out56 out55 out54 out53 out52 out51 out50 out49 out48 out47 out46 out45 out44 out43 out42 out41 out40 out39 out38 out37 out36 out35 out34 out33 out32 out31 out30 out29 out28 out27 out26 out25 out24 out23 out22 out21 out20 out19 out18 out17 out16 out15 out14 out13 out12 out11 out10 out9 out8 out7 out6 out5 out4 out3 out2 out1 out0
