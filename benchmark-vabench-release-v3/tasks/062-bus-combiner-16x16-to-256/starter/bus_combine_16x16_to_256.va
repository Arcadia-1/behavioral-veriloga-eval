`include "constants.vams"
`include "disciplines.vams"

module bus_combine_16x16_to_256(
    input electrical [15:0] in15,
    input electrical [15:0] in14,
    input electrical [15:0] in13,
    input electrical [15:0] in12,
    input electrical [15:0] in11,
    input electrical [15:0] in10,
    input electrical [15:0] in9,
    input electrical [15:0] in8,
    input electrical [15:0] in7,
    input electrical [15:0] in6,
    input electrical [15:0] in5,
    input electrical [15:0] in4,
    input electrical [15:0] in3,
    input electrical [15:0] in2,
    input electrical [15:0] in1,
    input electrical [15:0] in0,
    output electrical [255:0] out_bus
);
    parameter real vdd = 0.9;
    parameter real vth = 0.45;
    parameter real tr = 20p;

    genvar bit;

    analog begin
        for (bit = 0; bit < 16; bit = bit + 1) begin
            V(out_bus[0 + bit]) <+ transition(0.0, 0, tr, tr);
            V(out_bus[16 + bit]) <+ transition(0.0, 0, tr, tr);
            V(out_bus[32 + bit]) <+ transition(0.0, 0, tr, tr);
            V(out_bus[48 + bit]) <+ transition(0.0, 0, tr, tr);
            V(out_bus[64 + bit]) <+ transition(0.0, 0, tr, tr);
            V(out_bus[80 + bit]) <+ transition(0.0, 0, tr, tr);
            V(out_bus[96 + bit]) <+ transition(0.0, 0, tr, tr);
            V(out_bus[112 + bit]) <+ transition(0.0, 0, tr, tr);
            V(out_bus[128 + bit]) <+ transition(0.0, 0, tr, tr);
            V(out_bus[144 + bit]) <+ transition(0.0, 0, tr, tr);
            V(out_bus[160 + bit]) <+ transition(0.0, 0, tr, tr);
            V(out_bus[176 + bit]) <+ transition(0.0, 0, tr, tr);
            V(out_bus[192 + bit]) <+ transition(0.0, 0, tr, tr);
            V(out_bus[208 + bit]) <+ transition(0.0, 0, tr, tr);
            V(out_bus[224 + bit]) <+ transition(0.0, 0, tr, tr);
            V(out_bus[240 + bit]) <+ transition(0.0, 0, tr, tr);
        end
    end
endmodule
