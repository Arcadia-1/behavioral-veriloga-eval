`include "disciplines.vams"

module offset_search_comparator (CLK, VOUT, VINP, VINN);

input CLK, VOUT;
output VINP, VINN;
electrical CLK, VOUT, VINP, VINN;

parameter real vdd = 0.9;
parameter real vcm = 0.45;

real vin = 0;
real step = 10m;
integer state = 1;
integer sign = 1;

analog begin
    @(cross(V(CLK) - 0.5 * vdd, -1)) begin
        sign = V(VOUT) < 0.5 * vdd;
        if ((state != sign) && (step > 0u))
            step = step / 2.0;
        state = sign;
        vin = vin + (2 * state - 1) * step;
    end

    V(VINP) <+ (vcm + 0.5 * vin);
    V(VINN) <+ (vcm - 0.5 * vin);
end

endmodule
