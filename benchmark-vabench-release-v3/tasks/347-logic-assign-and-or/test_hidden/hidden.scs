simulator lang=spectre
global 0
// Hidden AMS behavior skeleton for mixed-signal extension task.
tran tran stop=200n
