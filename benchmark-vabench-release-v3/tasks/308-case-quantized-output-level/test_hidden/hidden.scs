simulator lang=spectre
global 0

ahdl_include "case_quantized_output_level.va"

Vvin (vin 0) vsource type=pwl wave=[ 0n 0.10 9n 0.10 10n 0.10 19n 0.10 20n 0.30 29n 0.30 30n 0.55 39n 0.55 40n 0.80 55n 0.80 ]
Vmode (mode 0) vsource type=pwl wave=[ 0n 0 55n 0 ]
Vrst (rst 0) vsource type=pwl wave=[ 0n 0.9 8n 0.9 8.1n 0 55n 0 ]
Vclk (clk 0) vsource type=pwl wave=[ 0n 0 4.9n 0 5.0n 0.9 5.5n 0.9 5.6n 0 14.9n 0 15.0n 0.9 15.5n 0.9 15.6n 0 24.9n 0 25.0n 0.9 25.5n 0.9 25.6n 0 34.9n 0 35.0n 0.9 35.5n 0.9 35.6n 0 44.9n 0 45.0n 0.9 45.5n 0.9 45.6n 0 55n 0 ]

XDUT (vin clk mode rst out metric) case_quantized_output_level

tran tran stop=55n
save vin clk mode rst out metric
