`include "constants.vams"
`include "disciplines.vams"
`default_transition 30p

module vin_src(CLK, RST_N, VOUT_P, VOUT_N);
    input electrical CLK, RST_N;
    output electrical VOUT_P, VOUT_N;
    parameter real vdd = 0.9;
    parameter real vth = 0.45;
    parameter real ampl = 0.015;  // 1/10th of correct
    parameter real freq = 300e3;
    parameter real sigma = 0.01;
    parameter integer SEED = 0;

    real vp;
    analog begin
        @(cross(V(CLK) - vth, +1))
            vp = vdd/2 + ampl * sin(2.0 * `M_PI * freq * $abstime)
                      + sigma * $rdist_normal(SEED, 0, 1);
        V(VOUT_P) <+ transition(vp, 0);
        V(VOUT_N) <+ transition(vdd/2, 0);
    end
endmodule
