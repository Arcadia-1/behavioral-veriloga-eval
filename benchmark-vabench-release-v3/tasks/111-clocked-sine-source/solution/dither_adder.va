// Differential dither adder support component.
//
//   dither_diff = +DITHER_AMP when DPN > vth
//   dither_diff = -DITHER_AMP when DPN <= vth
//   VOUT_P = VRES_P + dither_diff / 2
//   VOUT_N = VRES_N - dither_diff / 2

`include "constants.vams"
`include "disciplines.vams"
`default_transition 30p

module dither_adder(
    input  electrical VRES_P,
    input  electrical VRES_N,
    input  electrical DPN,
    output electrical VOUT_P,
    output electrical VOUT_N
);

parameter real vdd        = 0.9;
parameter real vth        = 0.45;
parameter real DITHER_AMP = 0.014063;

real dither_diff;

analog begin
    @(initial_step) begin
        dither_diff = (V(DPN) > vth) ? DITHER_AMP : -DITHER_AMP;
    end
    @(cross(V(DPN) - vth, +1)) begin
        dither_diff = DITHER_AMP;
    end
    @(cross(V(DPN) - vth, -1)) begin
        dither_diff = -DITHER_AMP;
    end

    V(VOUT_P) <+ V(VRES_P) + 0.5 * transition(dither_diff, 0, 2p, 2p);
    V(VOUT_N) <+ V(VRES_N) - 0.5 * transition(dither_diff, 0, 2p, 2p);
end

endmodule
