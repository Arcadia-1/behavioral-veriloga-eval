// Support differential dither adder.
// Adds a signed differential dither term based on the DPN control level.
//
//   dither_diff = +DITHER_AMP  when DPN > vth
//   dither_diff = -DITHER_AMP  when DPN < vth
//   VOUT_P = VRES_P + dither_diff / 2
//   VOUT_N = VRES_N - dither_diff / 2

`include "constants.vams"
`include "disciplines.vams"
`default_transition 30p

module dither_adder(
    input  electrical VRES_P,
    input  electrical VRES_N,
    input  electrical DPN,
    output electrical VOUT_P,
    output electrical VOUT_N
);

parameter real vdd        = 0.9;
parameter real vth        = 0.45;
parameter real DITHER_AMP = 0.014063;

real dither_diff;

analog begin
    @(initial_step)
        $strobe("[dither_adder] INIT | DITHER_AMP=%.4fmV", DITHER_AMP*1e3);

    dither_diff = (V(DPN) > vth) ? DITHER_AMP : -DITHER_AMP;

    // Keep the residual inputs continuous while adding a static differential offset.
    V(VOUT_P) <+ V(VRES_P) + dither_diff * 0.5;
    V(VOUT_N) <+ V(VRES_N) - dither_diff * 0.5;
end

endmodule
