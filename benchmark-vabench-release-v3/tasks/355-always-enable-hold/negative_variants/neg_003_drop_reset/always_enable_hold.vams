module always_enable_hold(clk, rst, d, en, q);
    input clk, rst, d, en;
    output q;
    logic clk, rst, d, en, q;

    always @(posedge clk) begin if (en) q = d; end
endmodule
