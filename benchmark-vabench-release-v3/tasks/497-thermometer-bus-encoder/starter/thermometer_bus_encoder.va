`include "disciplines.vams"

module thermometer_bus_encoder(vin, t0, t1, t2, t3, t4, t5, t6, t7, t8, t9, t10, t11, t12, t13, t14, t15);
input vin;
output t0, t1, t2, t3, t4, t5, t6, t7, t8, t9, t10, t11, t12, t13, t14, t15;
electrical vin, t0, t1, t2, t3, t4, t5, t6, t7, t8, t9, t10, t11, t12, t13, t14, t15;

analog begin
    V(t0) <+ 0.0; V(t1) <+ 0.0; V(t2) <+ 0.0; V(t3) <+ 0.0;
    V(t4) <+ 0.0; V(t5) <+ 0.0; V(t6) <+ 0.0; V(t7) <+ 0.0;
    V(t8) <+ 0.0; V(t9) <+ 0.0; V(t10) <+ 0.0; V(t11) <+ 0.0;
    V(t12) <+ 0.0; V(t13) <+ 0.0; V(t14) <+ 0.0; V(t15) <+ 0.0;
end
endmodule
