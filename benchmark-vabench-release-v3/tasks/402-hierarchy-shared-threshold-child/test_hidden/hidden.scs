simulator lang=spectre
global 0

ahdl_include "v3_child_threshold.va"
ahdl_include "hierarchy_shared_threshold_child.va"

Vvin (vin 0) vsource type=pwl wave=[0 0.35 49n 0.35 50n 0.55 99n 0.55 100n 0.42 149n 0.42 150n 0.76 200n 0.76]
Vclk (clk 0) vsource dc=0.0
Vmode (mode 0) vsource dc=0.0
Vrst (rst 0) vsource dc=0.0

XDUT (vin clk mode rst out metric) hierarchy_shared_threshold_child

tran tran stop=160n
save vin clk mode rst out metric
