simulator lang=spectre
global 0

ahdl_include "laplace_zd_zero_den_filter.va"

Vvin (vin 0) vsource type=pwl wave=[0 0.0 60n 0.0 61n 0.75 240n 0.75 241n 0.35 500n 0.35]
Vclk (clk 0) vsource type=pwl wave=[0 0.0 99n 0.0 100n 1.0 149n 1.0 150n 0.0 249n 0.0 250n 1.0 299n 1.0 300n 0.0]
Vmode (mode 0) vsource dc=0.0
Vrst (rst 0) vsource dc=0.0

XDUT (vin clk mode rst out metric) laplace_zd_zero_den_filter

tran tran stop=500n
save vin clk mode rst out metric
