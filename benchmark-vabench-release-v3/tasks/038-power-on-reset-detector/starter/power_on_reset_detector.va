`include "constants.vams"
`include "disciplines.vams"

module power_on_reset_detector(clk, rst, vin, out, metric);
input clk, rst, vin;
output out, metric;
electrical clk, rst, vin, out, metric;
parameter real tr = 100p;
parameter real vth = 0.45;
parameter real vtrip = 0.62;

    // TODO: implement the behavior described in instruction.md.
    // This starter is intentionally incomplete; implement the instruction.md behavior.
endmodule
