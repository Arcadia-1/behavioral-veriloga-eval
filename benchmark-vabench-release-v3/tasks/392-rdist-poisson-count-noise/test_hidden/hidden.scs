simulator lang=spectre
global 0

ahdl_include "rdist_poisson_count_noise.va"

Vvin (vin 0) vsource type=pwl wave=[0 0.62 99n 0.62 100n 0.74 199n 0.74 200n 0.66 299n 0.66 300n 0.81 420n 0.81]
Vclk (clk 0) vsource type=pwl wave=[0 0.0 49n 0.0 50n 1.0 79n 1.0 80n 0.0 149n 0.0 150n 1.0 179n 1.0 180n 0.0 249n 0.0 250n 1.0 279n 1.0 280n 0.0 349n 0.0 350n 1.0 420n 1.0]
Vmode (mode 0) vsource dc=0.0
Vrst (rst 0) vsource dc=0.0

XDUT (vin clk mode rst out metric) rdist_poisson_count_noise

tran tran stop=420n
save vin clk mode rst out metric
