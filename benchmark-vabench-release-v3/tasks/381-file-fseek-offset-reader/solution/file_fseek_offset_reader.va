`include "constants.vams"
`include "disciplines.vams"

module file_fseek_offset_reader (
    input  electrical vin,
    input  electrical clk,
    input  electrical mode,
    input  electrical rst,
    output electrical out,
    output electrical metric
);
parameter real vth = 0.45;
parameter real vhi = 0.9;
parameter real tr = 200p;
real out_v;
real metric_v;
integer seek_hit_q;
integer fd;
integer seek_status;
integer parsed_count;
integer mode_value;
string line_buf;
analog begin
    @(initial_step) begin
        out_v = 0.0;
        metric_v = 0.0;
        seek_hit_q = 0;
        parsed_count = 0;
        mode_value = 0;
        fd = $fopen("config_lines.txt", "r");
        seek_status = $fseek(fd, 9, 0);
        $fgets(line_buf, fd);
        $fclose(fd);
        parsed_count = $sscanf(line_buf, "mode=%d", mode_value);
        if ((seek_status == 0) && (parsed_count == 1) && (mode_value == 1)) seek_hit_q = 1;
        else seek_hit_q = 0;
        if (seek_hit_q != 0) metric_v = vhi;
        else metric_v = 0.0;
    end
    @(cross(V(clk) - vth, +1)) begin
        if (V(rst) > vth) begin
            out_v = 0.0;
        end else begin
            if ((seek_hit_q != 0) && (V(vin) > vth)) out_v = vhi;
            else out_v = 0.0;
        end
    end
    V(out) <+ transition(out_v, 0.0, tr, tr);
    V(metric) <+ transition(metric_v, 0.0, tr, tr);
end
endmodule
