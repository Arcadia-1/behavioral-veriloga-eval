`include "disciplines.vams"

module vargain_diffamp_clip(sigin_p, sigin_n, sigctrl_p, sigctrl_n, sigout);

input sigin_p, sigin_n, sigctrl_p, sigctrl_n;
output sigout;
electrical sigin_p, sigin_n, sigctrl_p, sigctrl_n, sigout;

parameter real gain_const = 3.0;
parameter real sigout_high = 1.0;
parameter real sigout_low = -1.0;
parameter real sigin_offset = 0.05;

analog begin
    V(sigout) <+ 0.0;
end

endmodule
