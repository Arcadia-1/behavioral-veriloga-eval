`include "constants.vams"
`include "disciplines.vams"

module kcl_capacitor_ddt_current (inout electrical p, inout electrical n);
parameter real c = 1p;
analog begin
    I(p, n) <+ (ddt(V(p, n)) > 0.0 ? c * ddt(V(p, n)) : 0.0);
end
endmodule
