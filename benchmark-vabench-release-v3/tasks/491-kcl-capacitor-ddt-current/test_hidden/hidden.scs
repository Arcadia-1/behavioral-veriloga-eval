simulator lang=spectre
global 0

ahdl_include "kcl_capacitor_ddt_current.va"

Vin (p 0) vsource type=pwl wave=[0 0.0 20n 0.0 21n 0.5 80n 0.5 81n -0.2 160n -0.2]

XDUT (p 0) kcl_capacitor_ddt_current c=1p

tran tran stop=160n
save p
