simulator lang=spectre
global 0
// Visible AMS smoke skeleton. An AMS-capable evaluator supplies and compiles the candidate.
tran tran stop=80n
