module logic_assign_reduction(a, b, en, y);
    input a, b, en;
    output y;
    logic a, b, en, y;
    assign y = (a & b & en) & (a & !a);
endmodule
