`include "constants.vams"
`include "disciplines.vams"

module ac_stim_small_signal_source (
    input  electrical ctrl,
    input  electrical clk,
    output electrical out,
    output electrical metric
);
parameter real vth = 0.45;
parameter real vhi = 0.9;
parameter real tr = 200p;
parameter real mag = 1.0;
parameter real phase_rad = 0.0;
real metric_v;

analog begin
    @(initial_step) begin
        metric_v = 0.0;
    end

    V(out) <+ transition(0.25, 0.0, tr, tr);
    if (analysis("ac")) V(out) <+ ac_stim("ac", mag, phase_rad);

    @(cross(V(clk)-vth,+1)) metric_v = mag;

    V(metric) <+ transition(metric_v, 0.0, tr, tr);
end
endmodule
