simulator lang=spectre
global 0
ahdl_include "adc_zoom_timing_sequencer.va"
XDUT (rst s sar res intg clk_sar zoom clk_zoom rst_zoom) adc_zoom_timing_sequencer
tran tran stop=11.5n maxstep=20p
save rst s sar res intg clk_sar zoom clk_zoom rst_zoom
