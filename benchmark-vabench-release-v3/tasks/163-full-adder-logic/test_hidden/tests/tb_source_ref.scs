simulator lang=spectre
global 0

ahdl_include "full_adder_logic.va"

Vin1 (vin1 0) vsource type=pwl wave=[0 0.9 8n 0.9 8.1n 0 16n 0 16.1n 0.9 24n 0.9 24.1n 0.9 32n 0.9 32.1n 0 40n 0 40.1n 0 48n 0 48.1n 0.9 56n 0.9 56.1n 0 75n 0]
Vin2 (vin2 0) vsource type=pwl wave=[0 0.9 8n 0.9 8.1n 0.9 16n 0.9 16.1n 0 24n 0 24.1n 0.9 32n 0.9 32.1n 0 40n 0 40.1n 0.9 48n 0.9 48.1n 0 56n 0 56.1n 0 75n 0]
Vcin (vin_carry 0) vsource type=pwl wave=[0 0.9 8n 0.9 8.1n 0.9 16n 0.9 16.1n 0.9 24n 0.9 24.1n 0 32n 0 32.1n 0.9 40n 0.9 40.1n 0 48n 0 48.1n 0 56n 0 56.1n 0 75n 0]

XDUT (vin1 vin2 vin_carry vout_sum vout_carry) full_adder_logic

tran tran stop=70n maxstep=25p
save vin1 vin2 vin_carry vout_sum vout_carry
