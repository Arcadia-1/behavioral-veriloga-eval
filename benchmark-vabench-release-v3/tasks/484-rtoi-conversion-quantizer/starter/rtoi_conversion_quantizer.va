`include "constants.vams"
`include "disciplines.vams"

module rtoi_conversion_quantizer (
    input  electrical in,
    output electrical out
);
integer code;
analog begin
    code = $rtoi(8.0 * V(in));
    V(out) <+ transition(0.0, 0.0, 200p, 200p);
end
endmodule
