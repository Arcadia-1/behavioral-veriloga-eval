simulator lang=spectre
global 0

ahdl_include "rtoi_conversion_quantizer.va"

Vin (inp 0) vsource type=pwl wave=[0 0.00 20n 0.00 21n 0.25 60n 0.25 61n 0.625 100n 0.625 101n 1.10 130n 1.10 131n -0.10 160n -0.10]

XDUT (inp out) rtoi_conversion_quantizer

tran tran stop=160n
save inp out
