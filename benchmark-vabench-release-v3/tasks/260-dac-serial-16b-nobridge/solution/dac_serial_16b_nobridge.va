`include "disciplines.vams"
module dac_serial_16b_nobridge(clk_sample, clk_sarready, data, out);
input clk_sample, clk_sarready, data;
output out;
electrical clk_sample, clk_sarready, data, out;
parameter real vdd = 1.1;
parameter real vcm = 0.55;
real state;
integer counter;
analog begin
    @(initial_step) begin
        state = 0.0;
        counter = 1;
    end
    @(cross(V(clk_sample) - vcm, -1)) begin
        state = 0.0;
        counter = 1;
    end
    @(cross(V(clk_sarready) - vcm, -1)) begin
        if (counter == 1) state = state + 64.0 / 145.015625 * (V(data) > vcm ? 1.0 : 0.0);
        else if (counter == 2) state = state + 32.0 / 145.015625 * (V(data) > vcm ? 1.0 : 0.0);
        else if (counter == 3) state = state + 16.0 / 145.015625 * (V(data) > vcm ? 1.0 : 0.0);
        else if (counter == 4) state = state + 16.0 / 145.015625 * (V(data) > vcm ? 1.0 : 0.0);
        else if (counter == 5) state = state + 8.0 / 145.015625 * (V(data) > vcm ? 1.0 : 0.0);
        counter = counter + 1;
    end
    V(out) <+ transition(state * 2.0 * vdd - vdd, 1p, 1p, 1p);
end
endmodule
