`include "constants.vams"
`include "disciplines.vams"

module file_ftell_position_meter (
    input  electrical vin,
    input  electrical clk,
    input  electrical mode,
    input  electrical rst,
    output electrical out,
    output electrical metric
);
parameter real vth = 0.45;
parameter real vhi = 0.9;
parameter real tr = 200p;
real out_v;
real metric_v;
integer position_hit_q;
integer fd;
integer pos_q;
string line_buf;
analog begin
    @(initial_step) begin
        out_v = 0.0;
        metric_v = 0.0;
        position_hit_q = 0;
        fd = $fopen("config_lines.txt", "r");
        $fgets(line_buf, fd);
        pos_q = $ftell(fd);
        $fclose(fd);
        if (pos_q == 9) position_hit_q = 1;
        else position_hit_q = 0;
        if (position_hit_q != 0) metric_v = vhi;
        else metric_v = 0.0;
    end
    @(cross(V(clk) - vth, +1)) begin
        if (V(rst) > vth) begin
            out_v = 0.0;
        end else begin
            if ((position_hit_q != 0) && (V(vin) > vth)) out_v = vhi;
            else out_v = 0.0;
        end
    end
    V(out) <+ transition(out_v, 0.0, tr, tr);
    V(metric) <+ transition(metric_v, 0.0, tr, tr);
end
endmodule
