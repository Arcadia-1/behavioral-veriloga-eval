`include "constants.vams"
`include "disciplines.vams"

module ref_step_clk (
    inout  electrical VDD,
    inout  electrical VSS,
    output electrical CLK
);
    parameter real period_pre = 20n from (0:inf);
    parameter real period_post = 19.5n from (0:inf);
    parameter real t_switch = 2u from [0:inf);
    parameter real tedge = 100p from (0:inf);

    real vh;
    real vl;
    real next_t;
    real half_period;
    integer clk_state;

analog begin
    V(CLK) <+ transition(0.0, 0.0, tedge, tedge);
end

endmodule
