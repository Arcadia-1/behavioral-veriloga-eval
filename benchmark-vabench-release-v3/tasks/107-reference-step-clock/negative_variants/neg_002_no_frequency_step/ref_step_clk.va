`include "constants.vams"
`include "disciplines.vams"
module ref_step_clk(VDD, VSS, CLK);
    inout electrical VDD, VSS;
    output electrical CLK;
    parameter real period = 20n;
    parameter real tedge = 100p;
    real vh, vl, half_period, next_t;
    integer clk_state;
    analog begin
        vh = V(VDD); vl = V(VSS);
        @(initial_step) begin
            clk_state = 0; half_period = 0.5*period; next_t = $abstime + half_period;
        end
        @(timer(next_t)) begin
            clk_state = 1-clk_state;
            next_t = next_t + half_period;  // no frequency step
        end
        V(CLK) <+ vl + (vh-vl)*transition(clk_state,0,tedge,tedge);
    end
endmodule
