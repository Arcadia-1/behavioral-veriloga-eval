`include "constants.vams"
`include "disciplines.vams"
module ref_step_clk(VDD, VSS, CLK);
    inout electrical VDD, VSS;
    output electrical CLK;
    parameter real period_pre = 20n;
    parameter real period_post = 19.5n;
    parameter real t_switch = 2u;
    parameter real tedge = 100p;
    real vh, vl, half_period, next_t;
    integer clk_state;
    analog begin
        vh = V(VDD); vl = V(VSS);
        @(initial_step) begin
            clk_state = 0; half_period = 0.5*period_pre; next_t = $abstime + half_period;
        end
        @(timer(next_t)) begin
            // Always high for 3/4 of period (bad duty cycle)
            half_period = (next_t >= t_switch) ? 0.75*period_post : 0.75*period_pre;
            next_t = next_t + half_period;
        end
        V(CLK) <+ vl + (vh-vl)*transition(clk_state,0,tedge,tedge);
    end
endmodule
