simulator lang=spectre
global 0

ahdl_include "rf_source_info_registration.va"

Vin (inp 0) vsource type=pwl wave=[0 0.10 20n 0.10 21n 0.30 60n 0.30 61n 0.50 100n 0.50 101n -0.10 160n -0.10]

XDUT (inp out) rf_source_info_registration

tran tran stop=160n
save inp out
