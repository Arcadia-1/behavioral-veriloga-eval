simulator lang=spectre
global 0

ahdl_include "edge_interval_tdc_8b.va"

V_start (start 0) vsource type=pulse val0=0 val1=0.9 period=4n delay=300p rise=50p fall=50p width=600p
V_stop (stop 0) vsource type=pulse val0=0 val1=0.9 period=4n delay=1.4n rise=50p fall=50p width=600p

XDUT (start stop valid code0 code1 code2 code3 code4 code5 code6 code7) edge_interval_tdc_8b

tran tran stop=5n maxstep=100p
save start stop valid code0 code1 code2 code3 code4 code5 code6 code7
