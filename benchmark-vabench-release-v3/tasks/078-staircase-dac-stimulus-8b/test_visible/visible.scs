simulator lang=spectre
global 0

ahdl_include "staircase_dac_stimulus_8b.va"

V_clk (clk 0) vsource type=pulse val0=0 val1=0.9 period=1n delay=100p rise=20p fall=20p width=450p
V_rst (rst 0) vsource type=pulse val0=0.9 val1=0 period=20n delay=1n rise=50p fall=50p width=18n

XDUT (clk rst vout code0 code1 code2 code3 code4 code5 code6 code7) staircase_dac_stimulus_8b

tran tran stop=8n maxstep=100p
save clk rst vout code0 code1 code2 code3 code4 code5 code6 code7
