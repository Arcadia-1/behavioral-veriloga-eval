`include "constants.vams"
`include "disciplines.vams"

module case_clocked_range_bucket (
    input  electrical vin,
    input  electrical clk,
    input  electrical mode,
    input  electrical rst,
    output electrical out,
    output electrical metric
);
parameter real vth = 0.45;
parameter real vhi = 0.9;
parameter real tr = 200p;
real out_v;
real metric_v;
integer count_q;
integer state_q;
integer mode_hi;
analog begin
    @(initial_step) begin
        out_v = 0.0;
        metric_v = 0.0;
        count_q = 0;
        state_q = 0;
        mode_hi = 0;
    end
    @(cross(V(clk) - vth, +1) or cross(V(rst) - vth, +1)) begin
        if (V(rst) > vth) begin
            state_q = 0;
            out_v = 0.0;
            metric_v = 0.0;
        end else begin
            mode_hi = (V(mode) > vth) ? 1 : 0;
            state_q = (V(vin) < 0.30) ? 0 : ((V(vin) < 0.60) ? 1 : 2);
            case (state_q)
                0: begin out_v = 0.10 + 0.10 * mode_hi; metric_v = 0.10; end
                1: begin out_v = 0.45 + 0.10 * mode_hi; metric_v = 0.45; end
                default: begin out_v = 0.80 + 0.05 * mode_hi; metric_v = 0.80; end
            endcase
        end
    end
    V(out) <+ transition(out_v, 0.0, tr, tr);
    V(metric) <+ transition(metric_v, 0.0, tr, tr);
end
endmodule
