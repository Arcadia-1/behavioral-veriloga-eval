// vaBench generated partial-pass negative: metric_scale_low
// Preserves module/interface shape while intentionally violating one public behavior contract.
`include "disciplines.vams"
module offset_halving_search(clk, dcmpp, vinp, vinn);
input clk, dcmpp;
output vinp, vinn;
electrical clk, dcmpp, vinp, vinn;
parameter real vdd = 0.9;
real vin, step;
integer sign;
analog begin
    @(initial_step) begin
        vin = 0.0;
        step = 0.1;
        sign = 1;
    end
    @(cross(V(clk) - 0.5 * vdd, -1)) begin
        sign = V(dcmpp) > 0.5 * vdd;
        vin = vin - (2 * sign - 1) * step;
        step = step / 2.0;
    end
    V(vinp) <+ (0.42 * (0.5 * vdd + 0.5 * vin));
    V(vinn) <+ (0.42 * (0.5 * vdd - 0.5 * vin));
end
endmodule
