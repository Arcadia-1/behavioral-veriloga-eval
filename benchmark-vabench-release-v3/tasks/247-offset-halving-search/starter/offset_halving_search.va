`include "disciplines.vams"
module offset_halving_search(clk, dcmpp, vinp, vinn);
input clk, dcmpp;
output vinp, vinn;
electrical clk, dcmpp, vinp, vinn;
analog begin
    V(vinp) <+ 0.0;
    V(vinn) <+ 0.0;
end
endmodule
