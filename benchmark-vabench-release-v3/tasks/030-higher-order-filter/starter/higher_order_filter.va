`include "constants.vams"
`include "disciplines.vams"

module higher_order_filter(clk, rst, vin, out, metric);
input clk, rst, vin;
output out, metric;
electrical clk, rst, vin, out, metric;
parameter real tr = 100p;
parameter real gain = 1.8;
parameter real alpha = 0.18;

    // TODO: implement the behavior described in instruction.md.
    // This starter is intentionally incomplete; implement the required behavior.
endmodule
