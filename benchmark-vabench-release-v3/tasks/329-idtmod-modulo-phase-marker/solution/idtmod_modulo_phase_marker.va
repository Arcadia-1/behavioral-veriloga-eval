`include "constants.vams"
`include "disciplines.vams"

module idtmod_modulo_phase_marker (
    input  electrical vin,
    input  electrical clk,
    input  electrical mode,
    input  electrical rst,
    output electrical out,
    output electrical metric
);
parameter real vth = 0.45;
parameter real vhi = 0.9;
parameter real tr = 200p;
real out_v;
real metric_v;
integer count_q;
integer state_q;
real phase_q;
real freq_q;
real marker_width_q;
analog begin
    @(initial_step) begin
        out_v = 0.0;
        metric_v = 0.0;
        count_q = 0;
        state_q = 0;
    end
    freq_q = 0.5e6 + 0.5e6 * V(vin);
    phase_q = idtmod((V(rst) > vth) ? 0.0 : freq_q, 0.0, 0.25);
    marker_width_q = (V(mode) > vth) ? 0.05 : 0.025;
    if (V(rst) > vth) begin
        out_v = 0.0;
        metric_v = 0.0;
    end else begin
        out_v = vhi * phase_q / 0.25;
        metric_v = (phase_q < marker_width_q) ? vhi : 0.0;
    end
    V(out) <+ transition(out_v, 0.0, tr, tr);
    V(metric) <+ transition(metric_v, 0.0, tr, tr);
end
endmodule
