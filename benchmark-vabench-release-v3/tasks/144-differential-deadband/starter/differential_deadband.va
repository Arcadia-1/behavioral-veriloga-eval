`include "disciplines.vams"

module differential_deadband (sigin_p, sigin_n, sigout);

input sigin_p, sigin_n;
output sigout;
electrical sigin_p, sigin_n, sigout;

parameter real dead_high = 0.1;
parameter real dead_low = -0.1;
parameter real gain = 1;
parameter real leak = 0;

analog begin
    V(sigout) <+ 0;
end

endmodule
