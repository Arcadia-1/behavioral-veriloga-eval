// Hidden SAR ADC/DAC flow: varied sine frequency and longer run.
simulator lang=spectre
global 0

ahdl_include "sar_adc_weighted_8b.va"
ahdl_include "dac_weighted_8b.va"
ahdl_include "sh_ideal.va"

parameters vdd=0.9 fin=150e3

Vvdd (vdd 0) vsource dc=vdd
Vvss (vss 0) vsource dc=0

Vclks (clks 0) vsource type=pulse val0=0 val1=vdd period=20n                rise=500p fall=500p
Vrst_n (rst_n 0) vsource type=pwl wave=[0 0  79n 0  80n vdd  12000n vdd]
Vvin (vin 0) vsource type=sine sinedc=0.45 ampl=0.45 freq=fin

IADC (vin_sh clks rst_n dout_7 dout_6 dout_5 dout_4 dout_3 dout_2 dout_1 dout_0       bit_index trial_code_mon trial_vdac cmp_decision conv_done vin_sample)       sar_adc_weighted_8b vdd=vdd

IDAC (dout_7 dout_6 dout_5 dout_4 dout_3 dout_2 dout_1 dout_0 vout)       dac_weighted_8b vdd=vdd

ISH (vin clks vdd vss rst_n vin_sh) sh_ideal

tran tran stop=12u maxstep=5n
save vin vin_sh clks rst_n vout dout_7 dout_6 dout_5 dout_4 dout_3 dout_2 dout_1 dout_0      bit_index trial_code_mon trial_vdac cmp_decision conv_done vin_sample
