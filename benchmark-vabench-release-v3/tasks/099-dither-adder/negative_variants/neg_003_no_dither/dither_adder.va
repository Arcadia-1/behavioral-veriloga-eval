`include "constants.vams"
`include "disciplines.vams"
`default_transition 30p

module dither_adder(VRES_P, VRES_N, DPN, VOUT_P, VOUT_N);
    input electrical VRES_P, VRES_N, DPN;
    output electrical VOUT_P, VOUT_N;

    analog begin
        V(VOUT_P) <+ V(VRES_P);
        V(VOUT_N) <+ V(VRES_N);
    end
endmodule
