// Starter scaffold for a differential dither adder.
// The completed model should add a signed differential dither term based on DPN.
//
//   dither_diff = +DITHER_AMP  when DPN > vth
//   dither_diff = -DITHER_AMP  when DPN < vth
//   VOUT_P = VRES_P + dither_diff / 2
//   VOUT_N = VRES_N - dither_diff / 2

`include "constants.vams"
`include "disciplines.vams"
`default_transition 30p

module dither_adder(
    input  electrical VRES_P,
    input  electrical VRES_N,
    input  electrical DPN,
    output electrical VOUT_P,
    output electrical VOUT_N
);

parameter real vdd        = 0.9;
parameter real vth        = 0.45;
parameter real DITHER_AMP = 0.014063;

real dither_diff;

analog begin
    V(VOUT_P) <+ transition(0.0);
    V(VOUT_N) <+ transition(0.0);
end

endmodule
