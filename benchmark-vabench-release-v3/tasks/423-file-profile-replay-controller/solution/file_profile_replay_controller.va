`include "constants.vams"
`include "disciplines.vams"

module file_profile_replay_controller (
    input  electrical vin,
    input  electrical clk,
    input  electrical mode,
    input  electrical rst,
    output electrical out,
    output electrical metric
);
parameter real vth = 0.45;
parameter real vhi = 0.9;
parameter real tr = 200p;
real out_v;
real metric_v;
integer count_q;
integer fd;
integer pos0;
integer pos1;
integer nread;
string line_buf;
analog begin
    @(initial_step) begin
        out_v = 0.0;
        metric_v = 0.0;
        count_q = 0;
        fd = $fopen("stimulus_profile.txt", "r");
        pos0 = $ftell(fd);
        nread = $fgets(line_buf, fd);
        pos1 = $ftell(fd);
        $fseek(fd, pos0, 0);
        nread = nread + $fgets(line_buf, fd);
        $rewind(fd);
        $fclose(fd);
        metric_v = pos1 >= pos0 ? 1.0 : 0.0;
    end
    @(cross(V(clk) - vth, +1)) begin
        if (V(rst) > vth) begin
            out_v = 0.0;
            metric_v = 0.0;
            count_q = 0;
        end else begin
            out_v = V(vin) > vth ? vhi : 0.0;
            metric_v = metric_v + 0.01 * count_q;
            count_q = count_q + 1;
        end
    end
    V(out) <+ transition(out_v, 0.0, tr, tr);
    V(metric) <+ transition(metric_v, 0.0, tr, tr);
end
endmodule
