`include "disciplines.vams"
module dac4bit_bipolar_252m(d3, d2, d1, d0, vout);
input d3, d2, d1, d0;
output vout;
electrical d3, d2, d1, d0, vout;
analog begin
    V(vout) <+ 0.0;
end
endmodule
