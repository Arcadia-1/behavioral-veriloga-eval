`include "constants.vams"
`include "disciplines.vams"

module reset_sync_active_low(clk, rst_n, sync_rst_n);
    input clk, rst_n;
    output sync_rst_n;
    electrical clk, rst_n, sync_rst_n;

    parameter real vdd = 0.9;
    parameter real vth = 0.45;
    parameter real tr = 20p;

    analog begin
        V(sync_rst_n) <+ transition(0.0, 0, tr, tr);
    end
endmodule
