`include "constants.vams"
`include "disciplines.vams"

module ac_stim_phase_selector (
    input  electrical ctrl,
    input  electrical clk,
    output electrical out,
    output electrical metric
);
parameter real vth = 0.45;
parameter real vhi = 0.9;
parameter real tr = 200p;
real metric_v;
analog begin
    @(initial_step) metric_v = 0.0;
    // TODO: drive ctrl in transient and select ac_stim phase during analysis("ac").
    V(out) <+ transition(0.0, 0.0, tr, tr);
    V(metric) <+ transition(metric_v, 0.0, tr, tr);
end
endmodule
