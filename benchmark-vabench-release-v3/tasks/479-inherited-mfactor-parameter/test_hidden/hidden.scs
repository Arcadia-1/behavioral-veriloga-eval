simulator lang=spectre
global 0

ahdl_include "inherited_mfactor_parameter.va"

Vin (inp 0) vsource type=pwl wave=[0 0.00 20n 0.00 21n 0.20 60n 0.20 61n 0.40 100n 0.40 101n -0.10 160n -0.10]

XDUT (inp out) inherited_mfactor_parameter m=1.5

tran tran stop=160n
save inp out
