simulator lang=spectre
global 0
ahdl_include "dff_set_reset_hold.va"
Vck (ck 0) vsource type=pwl wave=[0 0 1n 0 1.05n 0.9 1.45n 0.9 1.50n 0 3n 0 3.05n 0.9 3.45n 0.9 3.50n 0 5n 0 5.05n 0.9 5.45n 0.9 5.50n 0 7n 0 7.05n 0.9 7.45n 0.9 7.50n 0]
Vd (d 0) vsource type=pwl wave=[0 0.9 2.8n 0.9 2.9n 0 4.8n 0 4.9n 0.9]
Vrn (rn 0) vsource type=pwl wave=[0 0.9 5.8n 0.9 5.85n 0 6.5n 0 6.55n 0.9]
Vsn (sn 0) vsource type=pwl wave=[0 0.9 6.8n 0.9 6.85n 0 7.6n 0 7.65n 0.9]
XDUT (ck d rn sn qp) dff_set_reset_hold
tran tran stop=6.4n maxstep=20p
save ck d rn sn qp
