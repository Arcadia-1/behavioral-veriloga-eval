`include "constants.vams"
`include "disciplines.vams"

module task_stateful_threshold_update (
    input  electrical vin,
    input  electrical clk,
    input  electrical mode,
    input  electrical rst,
    output electrical out,
    output electrical metric
);
parameter real vth = 0.45;
parameter real vhi = 0.9;
parameter real tr = 200p;
real out_v;
real metric_v;
real threshold_q;
task threshold_update;
    input real sample;
    input integer raise_mode;
    begin
        if (sample > threshold_q) out_v = vhi;
        else out_v = 0.0;
        metric_v = threshold_q;
        if (raise_mode != 0) begin
            threshold_q = threshold_q + 0.1;
            if (threshold_q > 0.75) threshold_q = 0.75;
        end
    end
endtask
analog begin
    @(initial_step) begin
        out_v = 0.0;
        metric_v = 0.0;
        threshold_q = vth;
    end
    @(cross(V(clk) - vth, +1)) begin
        if (V(rst) > vth) begin
            out_v = 0.0;
            metric_v = 0.0;
            threshold_q = vth;
        end else begin
            threshold_update(V(vin), V(mode) > vth);
        end
    end
    V(out) <+ transition(out_v, 0.0, tr, tr);
    V(metric) <+ transition(metric_v, 0.0, tr, tr);
end
endmodule
