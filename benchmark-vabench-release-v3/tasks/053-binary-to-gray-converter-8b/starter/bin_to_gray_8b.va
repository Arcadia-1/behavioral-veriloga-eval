`include "constants.vams"
`include "disciplines.vams"

module bin_to_gray_8b(
    input electrical [7:0] b,
    output electrical [7:0] g
);
    parameter real vdd = 0.9;
    parameter real vth = 0.45;
    parameter real tr = 20p;
    genvar i;
    analog begin
        for (i = 0; i < 8; i = i + 1) V(g[i]) <+ transition(0.0, 0, tr, tr);
    end
endmodule
