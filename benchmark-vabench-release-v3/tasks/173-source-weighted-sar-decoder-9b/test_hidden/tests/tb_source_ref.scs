simulator lang=spectre
global 0

ahdl_include "weighted_sar_decoder_9b.va"

Vd0 (d0 0) vsource type=pwl wave=[0 0 9.9n 0 10.1n 0.9 19.9n 0.9 20.1n 0.9 29.9n 0.9 30.1n 0.9 40n 0.9]
Vd1 (d1 0) vsource type=pwl wave=[0 0 9.9n 0 10.1n 0 19.9n 0 20.1n 0.9 29.9n 0.9 30.1n 0.9 40n 0.9]
Vd2 (d2 0) vsource type=pwl wave=[0 0 9.9n 0 10.1n 0.9 19.9n 0.9 20.1n 0 29.9n 0 30.1n 0.9 40n 0.9]
Vd3 (d3 0) vsource type=pwl wave=[0 0 9.9n 0 10.1n 0 19.9n 0 20.1n 0.9 29.9n 0.9 30.1n 0.9 40n 0.9]
Vd4 (d4 0) vsource type=pwl wave=[0 0 9.9n 0 10.1n 0.9 19.9n 0.9 20.1n 0 29.9n 0 30.1n 0.9 40n 0.9]
Vd5 (d5 0) vsource type=pwl wave=[0 0 9.9n 0 10.1n 0 19.9n 0 20.1n 0.9 29.9n 0.9 30.1n 0.9 40n 0.9]
Vd6 (d6 0) vsource type=pwl wave=[0 0 9.9n 0 10.1n 0.9 19.9n 0.9 20.1n 0 29.9n 0 30.1n 0.9 40n 0.9]
Vd7 (d7 0) vsource type=pwl wave=[0 0 9.9n 0 10.1n 0 19.9n 0 20.1n 0.9 29.9n 0.9 30.1n 0.9 40n 0.9]
Vd8 (d8 0) vsource type=pwl wave=[0 0 9.9n 0 10.1n 0.9 19.9n 0.9 20.1n 0 29.9n 0 30.1n 0.9 40n 0.9]

XDUT (d0 d1 d2 d3 d4 d5 d6 d7 d8 aout7b aout7b5 aout8b) weighted_sar_decoder_9b

tran tran stop=36n maxstep=20p
save d0 d1 d2 d3 d4 d5 d6 d7 d8 aout7b aout7b5 aout8b
