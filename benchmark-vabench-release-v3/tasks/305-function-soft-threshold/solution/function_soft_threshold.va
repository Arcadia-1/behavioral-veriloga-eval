`include "constants.vams"
`include "disciplines.vams"

module function_soft_threshold (
    input  electrical vin,
    input  electrical clk,
    input  electrical mode,
    input  electrical rst,
    output electrical out,
    output electrical metric
);
parameter real vth = 0.45;
parameter real vhi = 0.9;
parameter real tr = 200p;
real out_v;
real metric_v;
integer count_q;
integer state_q;
analog function real soft_threshold;
    input x;
    real x;
    begin
        soft_threshold = 0.45 + 0.45 * tanh(8.0 * (x - 0.45));
    end
endfunction
analog begin
    @(initial_step) begin
        out_v = 0.0;
        metric_v = 0.0;
        count_q = 0;
        state_q = 0;
    end
    @(cross(V(clk) - vth, +1)) begin
        out_v = soft_threshold(V(vin));
        metric_v = out_v;
    end
    V(out) <+ transition(out_v, 0.0, tr, tr);
    V(metric) <+ transition(metric_v, 0.0, tr, tr);
end
endmodule
