`include "constants.vams"
`include "disciplines.vams"

module bandgap_reference_macro_model(clk, rst, vin, out, metric);
input clk, rst, vin;
output out, metric;
electrical clk, rst, vin, out, metric;
parameter real tr = 100p;
parameter real vth = 0.45;
parameter real vstart = 0.58;
parameter real vref = 0.55;

    // TODO: implement the behavior described in instruction.md.
    // This starter is intentionally incomplete; implement the instruction.md behavior.
endmodule
