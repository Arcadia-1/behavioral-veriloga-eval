`include "constants.vams"
`include "disciplines.vams"

`define USE_HIGH_THRESHOLD 1
module directive_configurable_threshold (
    input  electrical vin,
    input  electrical clk,
    input  electrical mode,
    input  electrical rst,
    output electrical out,
    output electrical metric
);
parameter real vth = 0.45;
parameter real vhi = 0.9;
parameter real tr = 200p;
`ifdef USE_HIGH_THRESHOLD
parameter real base_th = 0.60;
`else
parameter real base_th = 0.40;
`endif
real out_v;
real metric_v;
real eff_th;
integer count_q;
integer state_q;
analog begin
    @(initial_step) begin
        out_v = 0.0;
        metric_v = 0.0;
        count_q = 0;
        state_q = 0;
    end
    eff_th = (V(mode) > vth) ? (base_th - 0.10) : base_th;
    @(cross(V(clk) - vth, +1)) begin
        if (V(rst) > vth) begin
            out_v = 0.0;
            metric_v = 0.0;
        end else begin
            out_v = (V(vin) > eff_th) ? vhi : 0.0;
            metric_v = eff_th;
        end
    end
    V(out) <+ transition(out_v, 0.0, tr, tr);
    V(metric) <+ transition(metric_v, 0.0, tr, tr);
end
endmodule
