`include "disciplines.vams"
module divide_by_eight_clock(vin, vout);
input vin; output vout; electrical vin,vout; parameter integer divisor=8; parameter real tdel=10p; parameter real tr=20p; parameter real tf=20p; parameter real vdd=0.9; parameter real vth=0.45; integer cnt;
analog begin @(initial_step) cnt=0; @(cross(V(vin)-vth,+1)) begin cnt=cnt+1; cnt=cnt%divisor; end V(vout)<+transition((cnt<divisor/2)?vdd:0.0,tdel,tr,tf); end
endmodule
