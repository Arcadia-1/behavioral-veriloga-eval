`include "constants.vams"
`include "disciplines.vams"

module analysis_aware_noise_metric (
    input  electrical ctrl,
    input  electrical clk,
    output electrical out,
    output electrical metric
);
parameter real vth = 0.45;
parameter real vhi = 0.9;
parameter real tr = 200p;
parameter real noise_power = 1.0e-12;
real metric_v;
integer count_q;
analog begin
    @(initial_step) begin
        metric_v = 0.0;
        count_q = 0;
    end

    V(out) <+ transition(0.5 * V(ctrl), 0.0, tr, tr);
    if (analysis("noise")) V(out) <+ 0.5 * white_noise(noise_power, "metric_noise");

    @(cross(V(clk)-vth,+1)) begin
        count_q = count_q + 1;
        metric_v = count_q / 16.0;
    end

    V(metric) <+ transition(metric_v, 0.0, tr, tr);
end
endmodule
