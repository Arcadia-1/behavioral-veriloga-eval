`include "constants.vams"
`include "disciplines.vams"

module task_event_counter_service (
    input  electrical vin,
    input  electrical clk,
    input  electrical mode,
    input  electrical rst,
    output electrical out,
    output electrical metric
);
parameter real vth = 0.45;
parameter real vhi = 0.9;
parameter real tr = 200p;
real out_v;
real metric_v;
real sum_v;
integer count_q;
task service_event;
    input real sample;
    input integer enabled;
    begin
        if (enabled != 0) begin
            count_q = count_q + 1;
            sum_v = sum_v + sample;
        end
        out_v = 0.15 * count_q;
        if (out_v > vhi) out_v = vhi;
        if (count_q > 0) metric_v = sum_v / count_q;
        else metric_v = 0.0;
    end
endtask
analog begin
    @(initial_step) begin
        out_v = 0.0;
        metric_v = 0.0;
        sum_v = 0.0;
        count_q = 0;
    end
    @(cross(V(clk) - vth, +1)) begin
        if (V(rst) > vth) begin
            out_v = 0.0;
            metric_v = 0.0;
            sum_v = 0.0;
            count_q = 0;
        end else begin
            service_event(V(vin), V(mode) > vth);
        end
    end
    V(out) <+ transition(out_v, 0.0, tr, tr);
    V(metric) <+ transition(metric_v, 0.0, tr, tr);
end
endmodule
