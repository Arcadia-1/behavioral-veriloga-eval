`include "constants.vams"
`include "disciplines.vams"

module temperature_environment_metric (
    input  electrical vin,
    input  electrical clk,
    input  electrical mode,
    input  electrical rst,
    output electrical out,
    output electrical metric
);
parameter real vth = 0.45;
parameter real vhi = 0.9;
parameter real tr = 200p;
real out_v;
real metric_v;
integer count_q;
analog begin
    @(initial_step) begin
        out_v = 0.0;
        metric_v = 0.0;
        count_q = 0;
    end
    @(cross(V(clk) - vth, +1)) begin
        if (V(rst) > vth) begin
            out_v = 0.0;
            metric_v = 0.0;
            count_q = 0;
        end else begin
            out_v = (V(rst) > 0.45 ? 0.25 : ($temperature / 300.0));
            metric_v = $temperature;
            count_q = count_q + 1;
        end
    end
    V(out) <+ transition(out_v, 0.0, tr, tr);
    V(metric) <+ transition(metric_v, 0.0, tr, tr);
end
endmodule
