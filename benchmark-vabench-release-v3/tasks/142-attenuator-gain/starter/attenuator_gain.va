`include "disciplines.vams"

module attenuator_gain (vin, vout);

input vin;
output vout;
electrical vin, vout;

parameter real attenuation = 0;

analog begin
    V(vout) <+ 0;
end

endmodule
