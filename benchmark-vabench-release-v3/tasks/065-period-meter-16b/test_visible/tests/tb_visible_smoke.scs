simulator lang=spectre
global 0

ahdl_include "period_meter_16b.va"

V_clk_in (clk_in 0) vsource type=pulse val0=0 val1=0.9 period=1n delay=100p rise=20p fall=20p width=450p

XDUT (clk_in valid period0 period1 period2 period3 period4 period5 period6 period7 period8 period9 period10 period11 period12 period13 period14 period15) period_meter_16b

tran tran stop=8n maxstep=100p
save clk_in valid period0 period1 period2 period3 period4 period5 period6 period7 period8 period9 period10 period11 period12 period13 period14 period15
