`include "constants.vams"
`include "disciplines.vams"

module therm_to_bin_8b(
    input electrical [255:0] th,
    output electrical [7:0] b,
    output electrical valid
);
    parameter real vdd = 0.9;
    parameter real vth = 0.45;
    parameter real tr = 20p;

    genvar i;

    analog begin
        for (i = 0; i < 8; i = i + 1) begin
            V(b[i]) <+ transition(0.0, 0, tr, tr);
        end
        V(valid) <+ transition(0.0, 0, tr, tr);
    end
endmodule
