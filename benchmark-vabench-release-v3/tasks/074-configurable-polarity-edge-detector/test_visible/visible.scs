simulator lang=spectre
global 0

ahdl_include "configurable_polarity_edge_detector.va"

V_sig (sig 0) vsource type=pulse val0=0 val1=0.9 period=4n delay=200p rise=50p fall=50p width=1.5n
V_rise_en (rise_en 0) vsource type=pulse val0=0 val1=0.9 period=4n delay=400p rise=50p fall=50p width=1.5n

XDUT (sig rise_en pulse) configurable_polarity_edge_detector

tran tran stop=8n maxstep=100p
save sig rise_en pulse
