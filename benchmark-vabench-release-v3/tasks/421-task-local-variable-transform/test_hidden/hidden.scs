simulator lang=spectre
global 0

ahdl_include "task_local_variable_transform.va"

Vvin (vin 0) vsource type=pwl wave=[0 1.15 149n 1.15 150n -0.25 249n -0.25 250n 0.62 349n 0.62 350n 0.95 449n 0.95 450n 0.18 550n 0.18]
Vclk (clk 0) vsource type=pwl wave=[0 0.0 99n 0.0 100n 1.0 149n 1.0 150n 0.0 199n 0.0 200n 1.0 249n 1.0 250n 0.0 299n 0.0 300n 1.0 349n 1.0 350n 0.0 399n 0.0 400n 1.0 449n 1.0 450n 0.0 499n 0.0 500n 1.0 550n 1.0]
Vmode (mode 0) vsource dc=0.0
Vrst (rst 0) vsource type=pwl wave=[0 0.0 349n 0.0 350n 1.0 429n 1.0 430n 0.0 550n 0.0]

XDUT (vin clk mode rst out metric) task_local_variable_transform

tran tran stop=550n
save vin clk mode rst out metric
