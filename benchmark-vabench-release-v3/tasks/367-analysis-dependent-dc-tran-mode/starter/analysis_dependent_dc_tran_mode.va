`include "constants.vams"
`include "disciplines.vams"

module analysis_dependent_dc_tran_mode (
    input  electrical ctrl,
    input  electrical clk,
    output electrical out,
    output electrical metric
);
parameter real vth = 0.45;
parameter real vhi = 0.9;
parameter real tr = 200p;
real metric_v;
analog begin
    @(initial_step) begin
        metric_v = 0.0;
    end
    // TODO: use analysis("dc") and analysis("tran") to select the out contribution.
    V(out) <+ 0.0;
    V(metric) <+ transition(metric_v, 0.0, tr, tr);
end
endmodule
