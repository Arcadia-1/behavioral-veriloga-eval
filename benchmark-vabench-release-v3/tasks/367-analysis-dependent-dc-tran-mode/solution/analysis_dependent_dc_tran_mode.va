`include "constants.vams"
`include "disciplines.vams"

module analysis_dependent_dc_tran_mode (
    input  electrical ctrl,
    input  electrical clk,
    output electrical out,
    output electrical metric
);
parameter real vth = 0.45;
parameter real vhi = 0.9;
parameter real tr = 200p;
real metric_v;

analog begin
    @(initial_step) begin
        metric_v = 0.0;
    end

    V(out) <+ (analysis("dc") ? 0.25 : (analysis("tran") ? V(ctrl) : 0.0));

    @(cross(V(clk)-vth,+1)) metric_v = analysis("tran") ? vhi : 0.0;

    V(metric) <+ transition(metric_v, 0.0, tr, tr);
end
endmodule
