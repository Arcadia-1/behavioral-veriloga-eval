simulator lang=spectre
global 0

ahdl_include "zi_zd_discrete_filter.va"

Vvin (vin 0) vsource type=pwl wave=[0 0.0 50n 0.0 51n 0.55 230n 0.55 231n 0.85 500n 0.85]
Vclk (clk 0) vsource type=pwl wave=[0 0.0 99n 0.0 100n 1.0 149n 1.0 150n 0.0 249n 0.0 250n 1.0 299n 1.0 300n 0.0 399n 0.0 400n 1.0 449n 1.0 450n 0.0]
Vmode (mode 0) vsource dc=0.0
Vrst (rst 0) vsource dc=0.0

XDUT (vin clk mode rst out metric) zi_zd_discrete_filter

tran tran stop=500n
save vin clk mode rst out metric
