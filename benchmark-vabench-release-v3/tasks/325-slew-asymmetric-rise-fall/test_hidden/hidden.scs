simulator lang=spectre
global 0

ahdl_include "slew_asymmetric_rise_fall.va"

Vvin (vin 0) vsource type=pwl wave=[ 0n 0.0 65n 0.0 ]
Vmode (mode 0) vsource type=pwl wave=[ 0n 0.0 39n 0.0 40n 0.9 65n 0.9 ]
Vrst (rst 0) vsource type=pwl wave=[ 0n 0.9 12n 0.9 12.1n 0 65n 0 ]
Vclk (clk 0) vsource type=pwl wave=[ 0n 0 4.9n 0 5.0n 0.9 5.5n 0.9 5.6n 0 24.9n 0 25.0n 0.9 25.5n 0.9 25.6n 0 44.9n 0 45.0n 0.9 45.5n 0.9 45.6n 0 65n 0 ]

XDUT (vin clk mode rst out metric) slew_asymmetric_rise_fall

tran tran stop=65n
save vin clk mode rst out metric
