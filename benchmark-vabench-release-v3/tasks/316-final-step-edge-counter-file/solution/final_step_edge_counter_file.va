`include "constants.vams"
`include "disciplines.vams"

module final_step_edge_counter_file (
    input  electrical vin,
    input  electrical clk,
    input  electrical mode,
    input  electrical rst,
    output electrical out,
    output electrical metric
);
parameter real vth = 0.45;
parameter real vhi = 0.9;
parameter real tr = 200p;
real out_v;
real metric_v;
integer count_q;
integer state_q;
integer fd;
real metric_q;
analog begin
    @(initial_step) begin
        out_v = 0.0;
        metric_v = 0.0;
        count_q = 0;
        state_q = 0;
        metric_q = 0.0;
    end
    @(cross(V(clk) - vth, +1) or cross(V(rst) - vth, +1)) begin
        if (V(rst) > vth) begin
            count_q = 0;
            state_q = 0;
            metric_q = 0.0;
            out_v = 0.0;
            metric_v = 0.0;
        end else begin
            count_q = count_q + 1;
            state_q = count_q;
            metric_q = count_q / 4.0;
            if (metric_q > 1.0) metric_q = 1.0;
            out_v = vhi * metric_q;
            metric_v = metric_q;
            $strobe("edge_count count=%0d metric=%g", count_q, metric_q);
        end
    end
    @(final_step) begin
        fd = $fopen("candidate.out", "w");
        $fwrite(fd, "count=%0d metric=%.3f", count_q, metric_q);
        $fclose(fd);
    end
    V(out) <+ transition(out_v, 0.0, tr, tr);
    V(metric) <+ transition(metric_v, 0.0, tr, tr);
end
endmodule
