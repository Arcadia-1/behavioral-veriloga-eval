`include "constants.vams"
`include "disciplines.vams"

module config_shift_reg_64b(
    input electrical clk,
    input electrical rst_n,
    input electrical serial_in,
    output electrical [63:0] q
);
    parameter real vdd = 0.9;
    parameter real vth = 0.45;
    parameter real tr = 20p;
    genvar i;
    analog begin
        for (i = 0; i < 64; i = i + 1) begin
            V(q[i]) <+ transition(0.0, 0, tr, tr);
        end
    end
endmodule
