`include "constants.vams"
`include "disciplines.vams"

module random_seeded_dither_source (
    input  electrical vin,
    input  electrical clk,
    input  electrical mode,
    input  electrical rst,
    output electrical out,
    output electrical metric
);
parameter real vth = 0.45;
parameter real vhi = 0.9;
parameter real tr = 200p;
real out_v;
real metric_v;
integer count_q;
integer state_q;
analog begin
    @(initial_step) begin
        out_v = 0.0;
        metric_v = 0.0;
        count_q = 0;
        state_q = 0;
    end
    @(cross(V(clk) - vth, +1)) begin
        count_q = count_q + 1;
        out_v = V(vin) + 0.01 * ($random(count_q) % 5);
        if (out_v < 0.0) out_v = 0.0;
        if (out_v > vhi) out_v = vhi;
        metric_v = out_v;
    end
    V(out) <+ transition(out_v, 0.0, tr, tr);
    V(metric) <+ transition(metric_v, 0.0, tr, tr);
end
endmodule
