simulator lang=spectre
global 0

ahdl_include "random_seeded_dither_source.va"

Vvin (vin 0) vsource type=pwl wave=[0 0.22 180n 0.22 181n 0.58 399n 0.58 400n 0.36 650n 0.36]
Vmode (mode 0) vsource type=pwl wave=[0 0.9 199n 0.9 200n 0.0 399n 0.0 400n 0.9 650n 0.9]
Vrst (rst 0) vsource type=pwl wave=[0 0.0 449n 0.0 450n 0.9 529n 0.9 530n 0.0 650n 0.0]
Vclk (clk 0) vsource type=pwl wave=[0 0.0 99n 0.0 100n 0.9 120n 0.9 121n 0.0 299n 0.0 300n 0.9 320n 0.9 321n 0.0 499n 0.0 500n 0.9 520n 0.9 521n 0.0]

XDUT (vin clk mode rst out metric) random_seeded_dither_source

tran tran stop=650n
save vin clk mode rst out metric
