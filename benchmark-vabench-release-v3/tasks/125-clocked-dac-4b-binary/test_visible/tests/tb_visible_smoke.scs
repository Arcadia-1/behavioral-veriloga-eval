simulator lang=spectre
global 0

ahdl_include "clocked_dac_4b_binary.va"

Vclk (clk 0) vsource type=pulse val0=0 val1=0.9 delay=5n period=10n width=4n rise=100p fall=100p
Vd1 (d1 0) vsource type=pwl wave=[0 0 21n 0 21.1n 0.9 60n 0.9]
Vd2 (d2 0) vsource type=pwl wave=[0 0 11n 0 11.1n 0.9 21n 0.9 21.1n 0 31n 0 31.1n 0.9 60n 0.9]
Vd3 (d3 0) vsource type=pwl wave=[0 0 21n 0 21.1n 0.9 60n 0.9]
Vd4 (d4 0) vsource type=pwl wave=[0 0 11n 0 11.1n 0.9 21n 0.9 21.1n 0 31n 0 31.1n 0.9 60n 0.9]

XDUT (d1 d2 d3 d4 clk vout) clocked_dac_4b_binary

tran tran stop=45n maxstep=25p
save clk d1 d2 d3 d4 vout
