`include "constants.vams"
`include "disciplines.vams"

module cross_event_post_side_read(vin, state);
    input vin;
    output state;
    electrical vin, state;

    parameter real vth = 0.45;
    parameter real vdd = 0.9;
    parameter real tr = 20p;

    integer level;

    analog begin
        @(initial_step) begin
            level = 0;
        end

        @(cross(V(vin) - vth, +1) or cross(V(vin) - vth, -1)) begin
            level = (V(vin) > vth) ? 1 : 0;
            $strobe("[cross_event_post_side_read] t=%.3f ns | vin=%.6f | level=%d",
                    $abstime * 1e9, V(vin), level);
        end

        V(state) <+ transition(level ? vdd : 0.0, 0, tr, tr);
    end
endmodule
