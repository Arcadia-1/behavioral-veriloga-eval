// clk_burst_gen private coverage testbench
// 80 ns input clock period, div=8, reset releases after a non-frame-aligned delay.
simulator lang=spectre
global 0

ahdl_include "./dut/clk_burst_gen.va"

VCLK   (CLK   0) vsource type=pulse val0=0 val1=0.9 period=80n width=40n rise=800p fall=800p
VRST_N (RST_N 0) vsource type=pwl wave=[0 0  151n 0  152n 0.9  2200n 0.9]

IDUT (CLK RST_N CLK_OUT) clk_burst_gen div=8 vdd=0.9 vth=0.45

tran tran stop=2200n maxstep=4n
save CLK RST_N CLK_OUT
