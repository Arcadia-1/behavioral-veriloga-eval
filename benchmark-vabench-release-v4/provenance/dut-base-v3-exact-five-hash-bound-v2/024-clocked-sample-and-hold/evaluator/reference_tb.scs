simulator lang=spectre
global 0

ahdl_include "./dut/sample_hold.va"

// Clocked sample-and-hold reference testbench.
// The input is stable at each rising sampling edge, then steps well inside
// the high clock phase. A correct edge-sampled S/H holds the old value;
// high-phase-transparent mutations visibly follow the step.

Vvdd (vdd 0) vsource dc=1.0 type=dc
Vvss (vss 0) vsource dc=0.1 type=dc

Vin (in vss) vsource type=pwl wave=[ \
    0       0.10 \
    3.8n    0.10 \
    4.0n    0.78 \
    19.8n   0.78 \
    20.0n   0.78 \
    23.8n   0.78 \
    24.0n   0.22 \
    39.8n   0.22 \
    40.0n   0.22 \
    43.8n   0.22 \
    44.0n   0.72 \
    59.8n   0.72 \
    60.0n   0.72 \
    63.8n   0.72 \
    64.0n   0.30 \
    1u      0.30 \
]

Vclk (clk vss) vsource type=pulse val0=0 val1=0.9 period=20n width=10n rise=200p fall=200p

IDUT (vdd vss in clk out) sample_hold vth=0.45 tedge=100p

tran tran stop=1u maxstep=1n
save vdd vss in clk out
