simulator lang=spectre
global 0

ahdl_include "./dut/final_step_file_metric_ref.va"

Vvdd (vdd 0) vsource dc=0.9 type=dc
Vvss (vss 0) vsource dc=0.0 type=dc
Vref (ref 0) vsource type=pulse val0=0 val1=0.9 delay=10n period=20n width=2n rise=50p fall=50p
IDUT (vdd vss ref metric_out) final_step_file_metric_ref

simulatorOptions options evas_profile=balanced

tran tran stop=80n maxstep=20p errpreset=conservative
save vdd vss ref metric_out
