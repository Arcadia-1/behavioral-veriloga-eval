simulator lang=spectre
global 0

ahdl_include "./dut/cmp_strongarm.va"

// StrongARM-style latch comparator reference testbench.
// Exercises positive, negative, latch-hold, falling reset, and an explicit
// zero-differential decision cycle so >=-threshold tie-breaking mutations are
// behaviorally observable.

Vvdd (vdd 0) vsource dc=0.9 type=dc
Vgnd (vss 0) vsource dc=0.0 type=dc

// Evaluate on rising edges at 0.5ns, 1.5ns, ... and reset on falling edges.
Vclk (clk 0) vsource type=pulse val0=0 val1=0.9 period=1n delay=0.5n \
        rise=20p fall=20p width=480p

// VCM=0.45V. The first four decisions alternate polarity; the fifth edge has
// exact zero differential and must leave both decision outputs low.
Vvinp (vinp 0) vsource type=pwl wave=[ \
    0      0.451 \
    0.74n  0.451 \
    0.76n  0.449 \
    1.70n  0.449 \
    1.76n  0.451 \
    2.70n  0.451 \
    2.76n  0.449 \
    3.70n  0.449 \
    3.76n  0.449 \
    4.30n  0.450 \
    5.00n  0.450 \
]
Vvinn (vinn 0) vsource type=pwl wave=[ \
    0      0.449 \
    0.74n  0.449 \
    0.76n  0.451 \
    1.70n  0.451 \
    1.76n  0.449 \
    2.70n  0.449 \
    2.76n  0.451 \
    3.70n  0.451 \
    3.76n  0.451 \
    4.30n  0.450 \
    5.00n  0.450 \
]

// DUT (port order: CLK VINN VINP DCMPN DCMPP LP LM VSS VDD)
IDUT (clk vinn vinp out_n out_p lp lm vss vdd) cmp_strongarm

tran tran stop=5n maxstep=5p
save clk vinp vinn out_p out_n lp lm vss vdd
