simulator lang=spectre
global 0

ahdl_include "./dut/ptat_ctat_reference_generator.va"

Vclk (clk 0) vsource type=pulse val0=0 val1=0.9 period=2n width=1n rise=50p fall=50p
Vrst (rst 0) vsource type=pwl wave=[0 0.9 2n 0.9 2.1n 0 80n 0]
Vvin (vin 0) vsource type=pwl wave=[0 0.15 18n 0.15 18.1n 0.45 42n 0.45 42.1n 0.80 80n 0.80]

XDUT (clk rst vin out metric) ptat_ctat_reference_generator

tran tran stop=80n maxstep=0.5n
save clk rst vin out metric
