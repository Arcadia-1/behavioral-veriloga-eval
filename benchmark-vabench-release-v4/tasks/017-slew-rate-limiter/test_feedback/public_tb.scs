simulator lang=spectre
global 0

ahdl_include "slew_rate_limiter.va"

Vin (vin 0) vsource type=pwl wave=[ \
    0 0 \
    24.8n 0 25.2n 0.8 \
    92.8n 0.8 93.2n 0.1 \
    160n 0.1 \
]

XDUT (vin vout) slew_rate_limiter

tran tran stop=160n maxstep=500p
save vin vout
