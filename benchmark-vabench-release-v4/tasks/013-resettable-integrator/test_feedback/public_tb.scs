simulator lang=spectre
global 0

ahdl_include "resettable_integrator.va"

Vin (vin 0) vsource dc=0.003
Vrst (rst 0) vsource type=pwl wave=[ \
    0 0.9 \
    20n 0.9 20.2n 0 \
    220n 0 220.2n 0.9 \
    255n 0.9 255.2n 0 \
    320n 0 \
]

XDUT (vin rst vout) resettable_integrator

tran tran stop=320n maxstep=500p
save vin rst vout
