simulator lang=spectre
global 0

ahdl_include "./dut/charge_pump_abstraction.va"

Vclk (clk 0) vsource type=pulse val0=0 val1=0.9 period=2n width=1n rise=50p fall=50p
Vrst (rst 0) vsource type=pwl wave=[0 0.9 2n 0.9 2.1n 0 62n 0 62.1n 0.9 66n 0.9 66.1n 0 80n 0]
Vup (up 0) vsource type=pwl wave=[0 0 5.8n 0 5.85n 0.9 6.35n 0.9 6.4n 0 7.8n 0 7.85n 0.9 8.35n 0.9 8.4n 0 9.8n 0 9.85n 0.9 10.35n 0.9 10.4n 0 11.8n 0 11.85n 0.9 12.35n 0.9 12.4n 0 13.8n 0 13.85n 0.9 14.35n 0.9 14.4n 0 15.8n 0 15.85n 0.9 16.35n 0.9 16.4n 0 17.8n 0 17.85n 0.9 18.35n 0.9 18.4n 0 80n 0]
Vdn (dn 0) vsource type=pwl wave=[0 0 31.8n 0 31.85n 0.9 32.35n 0.9 32.4n 0 33.8n 0 33.85n 0.9 34.35n 0.9 34.4n 0 35.8n 0 35.85n 0.9 36.35n 0.9 36.4n 0 37.8n 0 37.85n 0.9 38.35n 0.9 38.4n 0 39.8n 0 39.85n 0.9 40.35n 0.9 40.4n 0 80n 0]

XDUT (clk rst up dn vctrl metric) charge_pump_abstraction

tran tran stop=80n maxstep=0.5n
save clk rst up dn vctrl metric
