simulator lang=spectre
global 0

ahdl_include "./dut/masked_config_update_32b.va"

Vold31 (old31 0) vsource type=pwl wave=[ 0n 0 9n 0 10n 0 19n 0 20n 0.9 29n 0.9 30n 0 39n 0 40n 0.9 49n 0.9 ]
Vold30 (old30 0) vsource type=pwl wave=[ 0n 0 9n 0 10n 0 19n 0 20n 0 29n 0 30n 0 39n 0 40n 0.9 49n 0.9 ]
Vold29 (old29 0) vsource type=pwl wave=[ 0n 0 9n 0 10n 0 19n 0 20n 0.9 29n 0.9 30n 0 39n 0 40n 0 49n 0 ]
Vold28 (old28 0) vsource type=pwl wave=[ 0n 0 9n 0 10n 0 19n 0 20n 0 29n 0 30n 0.9 39n 0.9 40n 0.9 49n 0.9 ]
Vold27 (old27 0) vsource type=pwl wave=[ 0n 0 9n 0 10n 0 19n 0 20n 0.9 29n 0.9 30n 0 39n 0 40n 0.9 49n 0.9 ]
Vold26 (old26 0) vsource type=pwl wave=[ 0n 0 9n 0 10n 0 19n 0 20n 0 29n 0 30n 0 39n 0 40n 0.9 49n 0.9 ]
Vold25 (old25 0) vsource type=pwl wave=[ 0n 0 9n 0 10n 0 19n 0 20n 0.9 29n 0.9 30n 0.9 39n 0.9 40n 0.9 49n 0.9 ]
Vold24 (old24 0) vsource type=pwl wave=[ 0n 0 9n 0 10n 0 19n 0 20n 0 29n 0 30n 0 39n 0 40n 0 49n 0 ]
Vold23 (old23 0) vsource type=pwl wave=[ 0n 0 9n 0 10n 0 19n 0 20n 0.9 29n 0.9 30n 0 39n 0 40n 0.9 49n 0.9 ]
Vold22 (old22 0) vsource type=pwl wave=[ 0n 0 9n 0 10n 0 19n 0 20n 0 29n 0 30n 0 39n 0 40n 0 49n 0 ]
Vold21 (old21 0) vsource type=pwl wave=[ 0n 0 9n 0 10n 0 19n 0 20n 0.9 29n 0.9 30n 0.9 39n 0.9 40n 0.9 49n 0.9 ]
Vold20 (old20 0) vsource type=pwl wave=[ 0n 0 9n 0 10n 0 19n 0 20n 0 29n 0 30n 0.9 39n 0.9 40n 0 49n 0 ]
Vold19 (old19 0) vsource type=pwl wave=[ 0n 0 9n 0 10n 0 19n 0 20n 0.9 29n 0.9 30n 0 39n 0 40n 0.9 49n 0.9 ]
Vold18 (old18 0) vsource type=pwl wave=[ 0n 0 9n 0 10n 0 19n 0 20n 0 29n 0 30n 0.9 39n 0.9 40n 0.9 49n 0.9 ]
Vold17 (old17 0) vsource type=pwl wave=[ 0n 0 9n 0 10n 0 19n 0 20n 0.9 29n 0.9 30n 0 39n 0 40n 0 49n 0 ]
Vold16 (old16 0) vsource type=pwl wave=[ 0n 0 9n 0 10n 0 19n 0 20n 0 29n 0 30n 0 39n 0 40n 0.9 49n 0.9 ]
Vold15 (old15 0) vsource type=pwl wave=[ 0n 0 9n 0 10n 0 19n 0 20n 0.9 29n 0.9 30n 0 39n 0 40n 0.9 49n 0.9 ]
Vold14 (old14 0) vsource type=pwl wave=[ 0n 0 9n 0 10n 0 19n 0 20n 0 29n 0 30n 0.9 39n 0.9 40n 0 49n 0 ]
Vold13 (old13 0) vsource type=pwl wave=[ 0n 0 9n 0 10n 0 19n 0 20n 0.9 29n 0.9 30n 0 39n 0 40n 0.9 49n 0.9 ]
Vold12 (old12 0) vsource type=pwl wave=[ 0n 0 9n 0 10n 0 19n 0 20n 0 29n 0 30n 0.9 39n 0.9 40n 0.9 49n 0.9 ]
Vold11 (old11 0) vsource type=pwl wave=[ 0n 0 9n 0 10n 0 19n 0 20n 0.9 29n 0.9 30n 0 39n 0 40n 0.9 49n 0.9 ]
Vold10 (old10 0) vsource type=pwl wave=[ 0n 0 9n 0 10n 0 19n 0 20n 0 29n 0 30n 0.9 39n 0.9 40n 0.9 49n 0.9 ]
Vold9 (old9 0) vsource type=pwl wave=[ 0n 0 9n 0 10n 0 19n 0 20n 0.9 29n 0.9 30n 0.9 39n 0.9 40n 0.9 49n 0.9 ]
Vold8 (old8 0) vsource type=pwl wave=[ 0n 0 9n 0 10n 0 19n 0 20n 0 29n 0 30n 0 39n 0 40n 0 49n 0 ]
Vold7 (old7 0) vsource type=pwl wave=[ 0n 0 9n 0 10n 0 19n 0 20n 0.9 29n 0.9 30n 0 39n 0 40n 0.9 49n 0.9 ]
Vold6 (old6 0) vsource type=pwl wave=[ 0n 0 9n 0 10n 0 19n 0 20n 0 29n 0 30n 0.9 39n 0.9 40n 0.9 49n 0.9 ]
Vold5 (old5 0) vsource type=pwl wave=[ 0n 0 9n 0 10n 0 19n 0 20n 0.9 29n 0.9 30n 0.9 39n 0.9 40n 0.9 49n 0.9 ]
Vold4 (old4 0) vsource type=pwl wave=[ 0n 0 9n 0 10n 0 19n 0 20n 0 29n 0 30n 0.9 39n 0.9 40n 0 49n 0 ]
Vold3 (old3 0) vsource type=pwl wave=[ 0n 0 9n 0 10n 0 19n 0 20n 0.9 29n 0.9 30n 0.9 39n 0.9 40n 0.9 49n 0.9 ]
Vold2 (old2 0) vsource type=pwl wave=[ 0n 0 9n 0 10n 0 19n 0 20n 0 29n 0 30n 0 39n 0 40n 0.9 49n 0.9 ]
Vold1 (old1 0) vsource type=pwl wave=[ 0n 0 9n 0 10n 0 19n 0 20n 0.9 29n 0.9 30n 0 39n 0 40n 0.9 49n 0.9 ]
Vold0 (old0 0) vsource type=pwl wave=[ 0n 0 9n 0 10n 0 19n 0 20n 0 29n 0 30n 0 39n 0 40n 0.9 49n 0.9 ]
Vnew31 (new31 0) vsource type=pwl wave=[ 0n 0.9 9n 0.9 10n 0.9 19n 0.9 20n 0 29n 0 30n 0.9 39n 0.9 40n 0 49n 0 ]
Vnew30 (new30 0) vsource type=pwl wave=[ 0n 0.9 9n 0.9 10n 0.9 19n 0.9 20n 0.9 29n 0.9 30n 0 39n 0 40n 0 49n 0 ]
Vnew29 (new29 0) vsource type=pwl wave=[ 0n 0.9 9n 0.9 10n 0.9 19n 0.9 20n 0 29n 0 30n 0 39n 0 40n 0 49n 0 ]
Vnew28 (new28 0) vsource type=pwl wave=[ 0n 0.9 9n 0.9 10n 0.9 19n 0.9 20n 0.9 29n 0.9 30n 0 39n 0 40n 0.9 49n 0.9 ]
Vnew27 (new27 0) vsource type=pwl wave=[ 0n 0.9 9n 0.9 10n 0.9 19n 0.9 20n 0 29n 0 30n 0 39n 0 40n 0 49n 0 ]
Vnew26 (new26 0) vsource type=pwl wave=[ 0n 0.9 9n 0.9 10n 0.9 19n 0.9 20n 0.9 29n 0.9 30n 0.9 39n 0.9 40n 0 49n 0 ]
Vnew25 (new25 0) vsource type=pwl wave=[ 0n 0.9 9n 0.9 10n 0.9 19n 0.9 20n 0 29n 0 30n 0.9 39n 0.9 40n 0.9 49n 0.9 ]
Vnew24 (new24 0) vsource type=pwl wave=[ 0n 0.9 9n 0.9 10n 0.9 19n 0.9 20n 0.9 29n 0.9 30n 0.9 39n 0.9 40n 0.9 49n 0.9 ]
Vnew23 (new23 0) vsource type=pwl wave=[ 0n 0.9 9n 0.9 10n 0.9 19n 0.9 20n 0 29n 0 30n 0 39n 0 40n 0 49n 0 ]
Vnew22 (new22 0) vsource type=pwl wave=[ 0n 0.9 9n 0.9 10n 0.9 19n 0.9 20n 0.9 29n 0.9 30n 0.9 39n 0.9 40n 0.9 49n 0.9 ]
Vnew21 (new21 0) vsource type=pwl wave=[ 0n 0.9 9n 0.9 10n 0.9 19n 0.9 20n 0 29n 0 30n 0.9 39n 0.9 40n 0 49n 0 ]
Vnew20 (new20 0) vsource type=pwl wave=[ 0n 0.9 9n 0.9 10n 0.9 19n 0.9 20n 0.9 29n 0.9 30n 0 39n 0 40n 0.9 49n 0.9 ]
Vnew19 (new19 0) vsource type=pwl wave=[ 0n 0.9 9n 0.9 10n 0.9 19n 0.9 20n 0 29n 0 30n 0 39n 0 40n 0 49n 0 ]
Vnew18 (new18 0) vsource type=pwl wave=[ 0n 0.9 9n 0.9 10n 0.9 19n 0.9 20n 0.9 29n 0.9 30n 0.9 39n 0.9 40n 0.9 49n 0.9 ]
Vnew17 (new17 0) vsource type=pwl wave=[ 0n 0.9 9n 0.9 10n 0.9 19n 0.9 20n 0 29n 0 30n 0 39n 0 40n 0.9 49n 0.9 ]
Vnew16 (new16 0) vsource type=pwl wave=[ 0n 0.9 9n 0.9 10n 0.9 19n 0.9 20n 0.9 29n 0.9 30n 0.9 39n 0.9 40n 0.9 49n 0.9 ]
Vnew15 (new15 0) vsource type=pwl wave=[ 0n 0.9 9n 0.9 10n 0.9 19n 0.9 20n 0 29n 0 30n 0 39n 0 40n 0.9 49n 0.9 ]
Vnew14 (new14 0) vsource type=pwl wave=[ 0n 0.9 9n 0.9 10n 0.9 19n 0.9 20n 0.9 29n 0.9 30n 0.9 39n 0.9 40n 0 49n 0 ]
Vnew13 (new13 0) vsource type=pwl wave=[ 0n 0.9 9n 0.9 10n 0.9 19n 0.9 20n 0 29n 0 30n 0 39n 0 40n 0 49n 0 ]
Vnew12 (new12 0) vsource type=pwl wave=[ 0n 0.9 9n 0.9 10n 0.9 19n 0.9 20n 0.9 29n 0.9 30n 0 39n 0 40n 0.9 49n 0.9 ]
Vnew11 (new11 0) vsource type=pwl wave=[ 0n 0.9 9n 0.9 10n 0.9 19n 0.9 20n 0 29n 0 30n 0 39n 0 40n 0.9 49n 0.9 ]
Vnew10 (new10 0) vsource type=pwl wave=[ 0n 0.9 9n 0.9 10n 0.9 19n 0.9 20n 0.9 29n 0.9 30n 0 39n 0 40n 0 49n 0 ]
Vnew9 (new9 0) vsource type=pwl wave=[ 0n 0.9 9n 0.9 10n 0.9 19n 0.9 20n 0 29n 0 30n 0.9 39n 0.9 40n 0.9 49n 0.9 ]
Vnew8 (new8 0) vsource type=pwl wave=[ 0n 0.9 9n 0.9 10n 0.9 19n 0.9 20n 0.9 29n 0.9 30n 0.9 39n 0.9 40n 0.9 49n 0.9 ]
Vnew7 (new7 0) vsource type=pwl wave=[ 0n 0.9 9n 0.9 10n 0.9 19n 0.9 20n 0 29n 0 30n 0 39n 0 40n 0.9 49n 0.9 ]
Vnew6 (new6 0) vsource type=pwl wave=[ 0n 0.9 9n 0.9 10n 0.9 19n 0.9 20n 0.9 29n 0.9 30n 0 39n 0 40n 0.9 49n 0.9 ]
Vnew5 (new5 0) vsource type=pwl wave=[ 0n 0.9 9n 0.9 10n 0.9 19n 0.9 20n 0 29n 0 30n 0.9 39n 0.9 40n 0 49n 0 ]
Vnew4 (new4 0) vsource type=pwl wave=[ 0n 0.9 9n 0.9 10n 0.9 19n 0.9 20n 0.9 29n 0.9 30n 0 39n 0 40n 0.9 49n 0.9 ]
Vnew3 (new3 0) vsource type=pwl wave=[ 0n 0.9 9n 0.9 10n 0.9 19n 0.9 20n 0 29n 0 30n 0 39n 0 40n 0.9 49n 0.9 ]
Vnew2 (new2 0) vsource type=pwl wave=[ 0n 0.9 9n 0.9 10n 0.9 19n 0.9 20n 0.9 29n 0.9 30n 0 39n 0 40n 0.9 49n 0.9 ]
Vnew1 (new1 0) vsource type=pwl wave=[ 0n 0.9 9n 0.9 10n 0.9 19n 0.9 20n 0 29n 0 30n 0 39n 0 40n 0.9 49n 0.9 ]
Vnew0 (new0 0) vsource type=pwl wave=[ 0n 0.9 9n 0.9 10n 0.9 19n 0.9 20n 0.9 29n 0.9 30n 0.9 39n 0.9 40n 0.9 49n 0.9 ]
Vmask31 (mask31 0) vsource type=pwl wave=[ 0n 0 9n 0 10n 0.9 19n 0.9 20n 0 29n 0 30n 0.9 39n 0.9 40n 0 49n 0 ]
Vmask30 (mask30 0) vsource type=pwl wave=[ 0n 0 9n 0 10n 0.9 19n 0.9 20n 0 29n 0 30n 0.9 39n 0.9 40n 0 49n 0 ]
Vmask29 (mask29 0) vsource type=pwl wave=[ 0n 0 9n 0 10n 0.9 19n 0.9 20n 0 29n 0 30n 0.9 39n 0.9 40n 0 49n 0 ]
Vmask28 (mask28 0) vsource type=pwl wave=[ 0n 0 9n 0 10n 0.9 19n 0.9 20n 0 29n 0 30n 0.9 39n 0.9 40n 0 49n 0 ]
Vmask27 (mask27 0) vsource type=pwl wave=[ 0n 0 9n 0 10n 0.9 19n 0.9 20n 0.9 29n 0.9 30n 0.9 39n 0.9 40n 0 49n 0 ]
Vmask26 (mask26 0) vsource type=pwl wave=[ 0n 0 9n 0 10n 0.9 19n 0.9 20n 0.9 29n 0.9 30n 0.9 39n 0.9 40n 0 49n 0 ]
Vmask25 (mask25 0) vsource type=pwl wave=[ 0n 0 9n 0 10n 0.9 19n 0.9 20n 0.9 29n 0.9 30n 0.9 39n 0.9 40n 0 49n 0 ]
Vmask24 (mask24 0) vsource type=pwl wave=[ 0n 0 9n 0 10n 0.9 19n 0.9 20n 0.9 29n 0.9 30n 0.9 39n 0.9 40n 0 49n 0 ]
Vmask23 (mask23 0) vsource type=pwl wave=[ 0n 0 9n 0 10n 0.9 19n 0.9 20n 0 29n 0 30n 0.9 39n 0.9 40n 0.9 49n 0.9 ]
Vmask22 (mask22 0) vsource type=pwl wave=[ 0n 0 9n 0 10n 0.9 19n 0.9 20n 0 29n 0 30n 0.9 39n 0.9 40n 0.9 49n 0.9 ]
Vmask21 (mask21 0) vsource type=pwl wave=[ 0n 0 9n 0 10n 0.9 19n 0.9 20n 0 29n 0 30n 0.9 39n 0.9 40n 0.9 49n 0.9 ]
Vmask20 (mask20 0) vsource type=pwl wave=[ 0n 0 9n 0 10n 0.9 19n 0.9 20n 0 29n 0 30n 0.9 39n 0.9 40n 0.9 49n 0.9 ]
Vmask19 (mask19 0) vsource type=pwl wave=[ 0n 0 9n 0 10n 0.9 19n 0.9 20n 0.9 29n 0.9 30n 0.9 39n 0.9 40n 0.9 49n 0.9 ]
Vmask18 (mask18 0) vsource type=pwl wave=[ 0n 0 9n 0 10n 0.9 19n 0.9 20n 0.9 29n 0.9 30n 0.9 39n 0.9 40n 0.9 49n 0.9 ]
Vmask17 (mask17 0) vsource type=pwl wave=[ 0n 0 9n 0 10n 0.9 19n 0.9 20n 0.9 29n 0.9 30n 0.9 39n 0.9 40n 0.9 49n 0.9 ]
Vmask16 (mask16 0) vsource type=pwl wave=[ 0n 0 9n 0 10n 0.9 19n 0.9 20n 0.9 29n 0.9 30n 0.9 39n 0.9 40n 0.9 49n 0.9 ]
Vmask15 (mask15 0) vsource type=pwl wave=[ 0n 0 9n 0 10n 0.9 19n 0.9 20n 0 29n 0 30n 0 39n 0 40n 0 49n 0 ]
Vmask14 (mask14 0) vsource type=pwl wave=[ 0n 0 9n 0 10n 0.9 19n 0.9 20n 0 29n 0 30n 0 39n 0 40n 0 49n 0 ]
Vmask13 (mask13 0) vsource type=pwl wave=[ 0n 0 9n 0 10n 0.9 19n 0.9 20n 0 29n 0 30n 0 39n 0 40n 0 49n 0 ]
Vmask12 (mask12 0) vsource type=pwl wave=[ 0n 0 9n 0 10n 0.9 19n 0.9 20n 0 29n 0 30n 0 39n 0 40n 0 49n 0 ]
Vmask11 (mask11 0) vsource type=pwl wave=[ 0n 0 9n 0 10n 0.9 19n 0.9 20n 0.9 29n 0.9 30n 0 39n 0 40n 0 49n 0 ]
Vmask10 (mask10 0) vsource type=pwl wave=[ 0n 0 9n 0 10n 0.9 19n 0.9 20n 0.9 29n 0.9 30n 0 39n 0 40n 0 49n 0 ]
Vmask9 (mask9 0) vsource type=pwl wave=[ 0n 0 9n 0 10n 0.9 19n 0.9 20n 0.9 29n 0.9 30n 0 39n 0 40n 0 49n 0 ]
Vmask8 (mask8 0) vsource type=pwl wave=[ 0n 0 9n 0 10n 0.9 19n 0.9 20n 0.9 29n 0.9 30n 0 39n 0 40n 0 49n 0 ]
Vmask7 (mask7 0) vsource type=pwl wave=[ 0n 0 9n 0 10n 0.9 19n 0.9 20n 0 29n 0 30n 0 39n 0 40n 0.9 49n 0.9 ]
Vmask6 (mask6 0) vsource type=pwl wave=[ 0n 0 9n 0 10n 0.9 19n 0.9 20n 0 29n 0 30n 0 39n 0 40n 0.9 49n 0.9 ]
Vmask5 (mask5 0) vsource type=pwl wave=[ 0n 0 9n 0 10n 0.9 19n 0.9 20n 0 29n 0 30n 0 39n 0 40n 0.9 49n 0.9 ]
Vmask4 (mask4 0) vsource type=pwl wave=[ 0n 0 9n 0 10n 0.9 19n 0.9 20n 0 29n 0 30n 0 39n 0 40n 0.9 49n 0.9 ]
Vmask3 (mask3 0) vsource type=pwl wave=[ 0n 0 9n 0 10n 0.9 19n 0.9 20n 0.9 29n 0.9 30n 0 39n 0 40n 0.9 49n 0.9 ]
Vmask2 (mask2 0) vsource type=pwl wave=[ 0n 0 9n 0 10n 0.9 19n 0.9 20n 0.9 29n 0.9 30n 0 39n 0 40n 0.9 49n 0.9 ]
Vmask1 (mask1 0) vsource type=pwl wave=[ 0n 0 9n 0 10n 0.9 19n 0.9 20n 0.9 29n 0.9 30n 0 39n 0 40n 0.9 49n 0.9 ]
Vmask0 (mask0 0) vsource type=pwl wave=[ 0n 0 9n 0 10n 0.9 19n 0.9 20n 0.9 29n 0.9 30n 0 39n 0 40n 0.9 49n 0.9 ]

XDUT (old31 old30 old29 old28 old27 old26 old25 old24 old23 old22 old21 old20 old19 old18 old17 old16 old15 old14 old13 old12 old11 old10 old9 old8 old7 old6 old5 old4 old3 old2 old1 old0 new31 new30 new29 new28 new27 new26 new25 new24 new23 new22 new21 new20 new19 new18 new17 new16 new15 new14 new13 new12 new11 new10 new9 new8 new7 new6 new5 new4 new3 new2 new1 new0 mask31 mask30 mask29 mask28 mask27 mask26 mask25 mask24 mask23 mask22 mask21 mask20 mask19 mask18 mask17 mask16 mask15 mask14 mask13 mask12 mask11 mask10 mask9 mask8 mask7 mask6 mask5 mask4 mask3 mask2 mask1 mask0 out31 out30 out29 out28 out27 out26 out25 out24 out23 out22 out21 out20 out19 out18 out17 out16 out15 out14 out13 out12 out11 out10 out9 out8 out7 out6 out5 out4 out3 out2 out1 out0) masked_config_update_32b

tran tran stop=50n maxstep=200p
save old31 old30 old29 old28 old27 old26 old25 old24 old23 old22 old21 old20 old19 old18 old17 old16 old15 old14 old13 old12 old11 old10 old9 old8 old7 old6 old5 old4 old3 old2 old1 old0 new31 new30 new29 new28 new27 new26 new25 new24 new23 new22 new21 new20 new19 new18 new17 new16 new15 new14 new13 new12 new11 new10 new9 new8 new7 new6 new5 new4 new3 new2 new1 new0 mask31 mask30 mask29 mask28 mask27 mask26 mask25 mask24 mask23 mask22 mask21 mask20 mask19 mask18 mask17 mask16 mask15 mask14 mask13 mask12 mask11 mask10 mask9 mask8 mask7 mask6 mask5 mask4 mask3 mask2 mask1 mask0 out31 out30 out29 out28 out27 out26 out25 out24 out23 out22 out21 out20 out19 out18 out17 out16 out15 out14 out13 out12 out11 out10 out9 out8 out7 out6 out5 out4 out3 out2 out1 out0
