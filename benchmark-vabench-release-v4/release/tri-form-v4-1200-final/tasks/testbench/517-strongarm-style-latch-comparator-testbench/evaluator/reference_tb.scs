simulator lang=spectre
global 0

ahdl_include "./dut/cmp_strongarm.va"

// StrongARM-style latch comparator:
// edge-sampled decisions, reset on falling CLK, and latch hold through
// within-evaluate input polarity swaps.

// Power supplies
Vvdd (vdd 0) vsource dc=0.9 type=dc
Vgnd (vss 0) vsource dc=0.0 type=dc

// Clock: evaluate on rising edges, reset on falling edges.
Vclk (clk 0) vsource type=pulse val0=0 val1=0.9 period=1n delay=0.5n \
        rise=20p fall=20p width=480p

// VCM=0.45V. The first two high phases swap input polarity after the edge
// so the checker can distinguish edge-latched behavior from a transparent comparator.
Vvinp (vinp 0) vsource type=pwl wave=[ \
    0      0.451 \
    0.74n  0.451 \
    0.76n  0.449 \
    1.70n  0.449 \
    1.76n  0.451 \
    2.70n  0.451 \
    2.76n  0.449 \
    4.10n  0.449 \
    4.12n  0.450 \
    5n     0.450 \
]
Vvinn (vinn 0) vsource type=pwl wave=[ \
    0      0.449 \
    0.74n  0.449 \
    0.76n  0.451 \
    1.70n  0.451 \
    1.76n  0.449 \
    2.70n  0.449 \
    2.76n  0.451 \
    4.10n  0.451 \
    4.12n  0.450 \
    5n     0.450 \
]

// DUT (port order: CLK VINN VINP DCMPN DCMPP LP LM VSS VDD)
IDUT (clk vinn vinp out_n out_p lp lm vss vdd) cmp_strongarm

tran tran stop=5n maxstep=5p
save clk vinp vinn out_p out_n lp lm vss vdd
