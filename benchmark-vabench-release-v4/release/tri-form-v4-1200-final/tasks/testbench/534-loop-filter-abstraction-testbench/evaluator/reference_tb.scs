simulator lang=spectre
global 0

ahdl_include "./dut/loop_filter_abstraction.va"

Vclk (clk 0) vsource type=pulse val0=0 val1=0.9 period=2n width=1n rise=50p fall=50p
Vrst (rst 0) vsource type=pwl wave=[0 0.9 2n 0.9 2.1n 0 62n 0 62.1n 0.9 66n 0.9 66.1n 0 80n 0]
Vvin (vin 0) vsource type=pwl wave=[0 0.45 8n 0.47 14n 0.43 20n 0.75 40n 0.18 58n 0.72 68n 0.47 74n 0.78 80n 0.78]

XDUT (clk rst vin out metric) loop_filter_abstraction

tran tran stop=80n maxstep=0.5n
save clk rst vin out metric
