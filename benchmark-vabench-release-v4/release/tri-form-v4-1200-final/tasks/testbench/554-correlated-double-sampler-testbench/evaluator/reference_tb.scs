simulator lang=spectre
global 0

ahdl_include "./dut/correlated_double_sampler.va"

Vphi_reset (phi_reset 0) vsource type=pwl wave=[0n 0 0.80n 0 0.82n 0.9 1.05n 0.9 1.07n 0 4.10n 0 4.12n 0.9 4.35n 0.9 4.37n 0 7.40n 0 7.42n 0.9 7.65n 0.9 7.67n 0 11.00n 0 11.02n 0.9 11.25n 0.9 11.27n 0]
Vphi_signal (phi_signal 0) vsource type=pwl wave=[0n 0 1.70n 0 1.72n 0.9 1.95n 0.9 1.97n 0 5.05n 0 5.07n 0.9 5.30n 0.9 5.32n 0 8.50n 0 8.52n 0.9 8.75n 0.9 8.77n 0 12.10n 0 12.12n 0.9 12.35n 0.9 12.37n 0]
Vvin (vin 0) vsource type=pwl wave=[0n 0.45 0.55n 0.45 0.57n 0.72 1.40n 0.72 1.42n 0.34 3.85n 0.34 3.87n 0.18 4.80n 0.18 4.82n 0.76 7.15n 0.76 7.17n 0.64 8.20n 0.64 8.22n 0.12 10.75n 0.12 10.77n 0.30 11.85n 0.30 11.87n 1.08 14n 1.08]

XDUT (phi_reset phi_signal vin vout valid) correlated_double_sampler

tran tran stop=14n maxstep=10p
save phi_reset phi_signal vin vout valid
