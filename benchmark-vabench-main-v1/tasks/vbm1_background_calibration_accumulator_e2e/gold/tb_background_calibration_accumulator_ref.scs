simulator lang=spectre
global 0

ahdl_include "background_calibration_accumulator.va"

Vclk (clk 0) vsource type=pulse val0=0 val1=0.9 delay=10n rise=200p fall=200p width=5n period=20n
Vrst (rst 0) vsource type=pwl wave=[0 0.9 15n 0.9 16n 0 220n 0]
Vsig (err 0) vsource type=pwl wave=[0 0.9 90n 0.9 91n 0 160n 0 161n 0.9 220n 0.9]

XDUT (clk rst err accum) background_calibration_accumulator

tran tran stop=220n maxstep=500p
save clk rst err accum
