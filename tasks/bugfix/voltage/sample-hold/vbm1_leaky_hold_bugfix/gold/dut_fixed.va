`include "constants.vams"
`include "disciplines.vams"

module leaky_hold(sample, rst, vout);
    input sample, rst;
    output vout;
    electrical sample, rst, vout;

    parameter real vth = 0.45;
    parameter real decay = 0.985;
    parameter real tr = 500p;

    real held;

    analog begin
        @(initial_step) held = 0.0;
        @(cross(V(sample) - vth, +1)) held = 0.75;
        @(timer(0, 1n)) begin
            if (V(rst) > vth)
                held = 0.0;
            else
                held = held * decay;
        end
        V(vout) <+ transition(held, 0, tr, tr);
    end
endmodule
