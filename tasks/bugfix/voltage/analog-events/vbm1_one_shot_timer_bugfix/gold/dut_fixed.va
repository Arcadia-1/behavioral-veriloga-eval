`include "constants.vams"
`include "disciplines.vams"

module one_shot_timer(trig, rst_n, pulse);
    input trig, rst_n;
    output pulse;
    electrical trig, rst_n, pulse;

    parameter real vth = 0.45;
    parameter real vdd = 0.9;
    parameter real tpw = 8n;
    parameter real tr = 200p;

    integer state;
    real clear_t;
    integer armed;

    analog begin
        @(initial_step) begin
            state = 0;
            clear_t = -1.0;
            armed = 0;
        end
        @(cross(V(rst_n) - vth, -1)) begin
            state = 0;
            armed = 0;
            clear_t = -1.0;
        end
        @(cross(V(trig) - vth, +1)) begin
            if (V(rst_n) > vth) begin
                state = 1;
                clear_t = $abstime + tpw;
                armed = 1;
            end
        end
        @(timer(clear_t)) begin
            if (armed) begin
                state = 0;
                armed = 0;
            end
        end
        V(pulse) <+ transition(state ? vdd : 0.0, 0, tr, tr);
    end
endmodule
