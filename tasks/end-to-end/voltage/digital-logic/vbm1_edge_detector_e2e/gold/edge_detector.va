`include "constants.vams"
`include "disciplines.vams"
module edge_detector(sig, rst_n, pulse);
    input sig,rst_n; output pulse; electrical sig,rst_n,pulse;
    parameter real vth=0.45; parameter real vdd=0.9; parameter real width=6n; parameter real tr=200p;
    integer state; real clear_t; integer armed;
    analog begin
        @(initial_step) begin state=0; clear_t=-1.0; armed=0; end
        @(cross(V(rst_n)-vth,-1)) begin state=0; armed=0; clear_t=-1.0; end
        @(cross(V(sig)-vth,+1)) begin if (V(rst_n)>vth) begin state=1; armed=1; clear_t=$abstime+width; end end
        @(timer(clear_t)) begin if (armed) begin state=0; armed=0; end end
        V(pulse) <+ transition(state ? vdd : 0.0,0,tr,tr);
    end
endmodule
