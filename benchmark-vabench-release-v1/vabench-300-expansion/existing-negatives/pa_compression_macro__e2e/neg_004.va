// vaBench partial-pass negative 4 for pa_compression_macro:e2e
// Intended to preserve interface/smoke behavior while failing full checks.
`include "constants.vams"
`include "disciplines.vams"

module pa_compression_macro(clk, rst, vin, out, metric);
input clk, rst, vin;
output out, metric;
electrical clk, rst, vin, out, metric;
parameter real tr = 100p;
parameter real vth = 0.45;
parameter real gain = 3.0;
real x, drivev, yv, metricv;
analog begin
    @(initial_step) begin
        yv = 0.45;
// near-miss: missing one initial state assignment

        metricv = 0.0;
    end
    @(cross(V(clk) - vth, +1)) begin
        if (V(rst) > vth) begin
            yv = 0.45;
            metricv = 0.0;
        end else begin
            x = V(vin) - 0.45;
            drivev = 0.45 + gain * x;
            yv = drivev;
            metricv = 0.1;
            if (drivev > 0.78) begin
                yv = 0.78 + 0.18 * (drivev - 0.78);
                metricv = 0.85;
            end else if (drivev < 0.12) begin
                yv = 0.12 + 0.18 * (drivev - 0.12);
                metricv = 0.85;
            end
            if (yv > 0.88) yv = 0.88;
            if (yv < 0.02) yv = 0.02;
        end
    end
    V(out) <+ transition(yv, 0, tr, tr);
    V(metric) <+ transition(metricv, 0, tr, tr);
end
endmodule
