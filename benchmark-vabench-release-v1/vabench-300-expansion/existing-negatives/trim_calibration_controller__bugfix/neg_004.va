// vaBench partial-pass negative 4 for trim_calibration_controller:bugfix
// Intended to preserve interface/smoke behavior while failing full checks.
`include "constants.vams"
`include "disciplines.vams"
module cdac_calibration(clk,rst,err,trim);
    input clk,rst,err; output trim; electrical clk,rst,err,trim;
    parameter real vth=0.45; parameter real tr=500p; real acc;
    analog begin
        @(initial_step) acc=0.45;
// near-miss: missing one initial state assignment

        @(cross(V(clk)-vth,+1)) begin
            if (V(rst)>vth) acc=0.45;
            else if (V(err)>vth) acc=acc-0.06; else acc=acc+0.06;
            if (acc>0.85) acc=0.85; if (acc<0.05) acc=0.05;
        end
        V(trim) <+ transition(acc,0,tr,tr);
    end
endmodule
