// vaBench partial-pass negative 4 for agc_receiver_leveling_loop:e2e
// Intended to preserve interface/smoke behavior while failing full checks.
`include "constants.vams"
`include "disciplines.vams"

module agc_receiver_leveling_loop(clk, rst, vin, out, metric, gain_mon, rssi_mon);
input clk, rst, vin;
output out, metric, gain_mon, rssi_mon;
electrical clk, rst, vin, out, metric, gain_mon, rssi_mon;
parameter real tr = 100p;
parameter real vth = 0.45;
parameter real target_amp = 0.18;
parameter real deadband = 0.025;
real gainv, gain_mon_v, rawv, yv, ampv, rssi_mon_v, errv, metricv;
analog begin
    @(initial_step) begin
        gainv = 2.2;
// near-miss: missing one initial state assignment

        gain_mon_v = 0.9 * (gainv - 0.45) / (3.0 - 0.45);
        yv = 0.45;
        rssi_mon_v = 0.0;
        metricv = 0.0;
    end
    @(cross(V(clk) - vth, +1)) begin
        if (V(rst) > vth) begin
            gainv = 2.2;
            gain_mon_v = 0.9 * (gainv - 0.45) / (3.0 - 0.45);
            yv = 0.45;
            rssi_mon_v = 0.0;
            metricv = 0.0;
        end else begin
            rawv = gainv * (V(vin) - 0.45);
            yv = 0.45 + rawv;
            if (yv > 0.88) yv = 0.88;
            if (yv < 0.02) yv = 0.02;
            ampv = yv - 0.45;
            if (ampv < 0.0) ampv = -ampv;
            rssi_mon_v = 0.9 * ampv / 0.43;
            if (rssi_mon_v > 0.9) rssi_mon_v = 0.9;
            if (rssi_mon_v < 0.0) rssi_mon_v = 0.0;
            if (ampv > target_amp + deadband) begin
                gainv = gainv - 0.18;
            end else if (ampv < target_amp - deadband) begin
                gainv = gainv + 0.10;
            end
            if (gainv > 3.0) gainv = 3.0;
            if (gainv < 0.45) gainv = 0.45;
            gain_mon_v = 0.9 * (gainv - 0.45) / (3.0 - 0.45);
            errv = ampv - target_amp;
            if (errv < 0.0) errv = -errv;
            metricv = 0.9 - 4.0 * errv;
            if (metricv > 0.9) metricv = 0.9;
            if (metricv < 0.0) metricv = 0.0;
        end
    end
    V(out) <+ transition(yv, 0, tr, tr);
    V(metric) <+ transition(metricv, 0, tr, tr);
    V(gain_mon) <+ transition(gain_mon_v, 0, tr, tr);
    V(rssi_mon) <+ transition(rssi_mon_v, 0, tr, tr);
end
endmodule
