// vaBench partial-pass negative 4 for lfsr_prbs_generator:bugfix
// Intended to preserve interface/smoke behavior while failing full checks.
`include "constants.vams"
`include "disciplines.vams"

// Reference PRBS-7 generator using a 7-bit LFSR.
// Serial output is the MSB state bit.
// Parallel outputs expose all 7 state bits individually.
module prbs7_ref (
    input  electrical clk,
    input  electrical rst_n,
    input  electrical en,
    output electrical serial_out,
    output electrical state_0,
    output electrical state_1,
    output electrical state_2,
    output electrical state_3,
    output electrical state_4,
    output electrical state_5,
    output electrical state_6
);

parameter real vdd = 0.9;
parameter real vth = 0.45;
parameter real trf = 10p;
parameter real td  = 0p;
// Use a plain decimal integer so EVAS and Spectre agree on the seed value.
parameter integer seed = 127;

integer state_0_i;
integer state_1_i;
integer state_2_i;
integer state_3_i;
integer state_4_i;
integer state_5_i;
integer state_6_i;
integer feedback;
integer serial_bit;

analog begin
    @(initial_step) begin
        state_0_i = (seed >> 0) & 1;
// near-miss: missing one initial state assignment

        state_1_i = (seed >> 1) & 1;
        state_2_i = (seed >> 2) & 1;
        state_3_i = (seed >> 3) & 1;
        state_4_i = (seed >> 4) & 1;
        state_5_i = (seed >> 5) & 1;
        state_6_i = (seed >> 6) & 1;
        if (state_0_i == 0 && state_1_i == 0 && state_2_i == 0 && state_3_i == 0 &&
            state_4_i == 0 && state_5_i == 0 && state_6_i == 0)
            state_6_i = 1;
    end

    @(cross(V(clk) - vth, +1)) begin
        if (V(rst_n) < vth) begin
            state_0_i = (seed >> 0) & 1;
            state_1_i = (seed >> 1) & 1;
            state_2_i = (seed >> 2) & 1;
            state_3_i = (seed >> 3) & 1;
            state_4_i = (seed >> 4) & 1;
            state_5_i = (seed >> 5) & 1;
            state_6_i = (seed >> 6) & 1;
            if (state_0_i == 0 && state_1_i == 0 && state_2_i == 0 && state_3_i == 0 &&
                state_4_i == 0 && state_5_i == 0 && state_6_i == 0)
                state_6_i = 1;
        end else if (V(en) > vth) begin
            feedback = state_6_i ^ state_4_i;
            state_6_i = state_5_i;
            state_5_i = state_4_i;
            state_4_i = state_3_i;
            state_3_i = state_2_i;
            state_2_i = state_1_i;
            state_1_i = state_0_i;
            state_0_i = feedback;
        end
    end

    serial_bit = state_6_i;

    V(serial_out) <+ transition(serial_bit ? vdd : 0.0, td, trf, trf);
    V(state_0)    <+ transition(state_0_i ? vdd : 0.0, td, trf, trf);
    V(state_1)    <+ transition(state_1_i ? vdd : 0.0, td, trf, trf);
    V(state_2)    <+ transition(state_2_i ? vdd : 0.0, td, trf, trf);
    V(state_3)    <+ transition(state_3_i ? vdd : 0.0, td, trf, trf);
    V(state_4)    <+ transition(state_4_i ? vdd : 0.0, td, trf, trf);
    V(state_5)    <+ transition(state_5_i ? vdd : 0.0, td, trf, trf);
    V(state_6)    <+ transition(state_6_i ? vdd : 0.0, td, trf, trf);
end

endmodule
