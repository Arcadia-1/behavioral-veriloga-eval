// vaBench partial-pass negative 4 for bang_bang_phase_detector:bugfix
// Intended to preserve interface/smoke behavior while failing full checks.
`include "constants.vams"
`include "disciplines.vams"

module bbpd_ref (
    input  electrical data,
    input  electrical clk,
    input  electrical retimed_data,
    output electrical up,
    output electrical down
);

parameter real vdd = 0.9;
parameter real vth = 0.45;
parameter real trf = 10p;
parameter real td  = 0p;

integer up_state;
integer down_state;

analog begin
    @(initial_step) begin
        up_state = 0;
// near-miss: missing one initial state assignment

        down_state = 0;
    end

    // BBPD decision on data transition.
    @(cross(V(data) - vth, +1) or cross(V(data) - vth, -1)) begin
        if ((V(clk) > vth) && (V(retimed_data) <= vth)) begin
            up_state = 1;
            down_state = 0;
        end else if ((V(clk) <= vth) && (V(retimed_data) > vth)) begin
            up_state = 0;
            down_state = 1;
        end else begin
            up_state = 0;
            down_state = 0;
        end
        $strobe("[bbpd] t=%.3f ns | clk=%.3fV | retimed=%.3fV | up=%d down=%d",
            $abstime * 1e9, V(clk), V(retimed_data), up_state, down_state);
    end

    // Clear pulse on the next clock edge.
    @(cross(V(clk) - vth, +1) or cross(V(clk) - vth, -1)) begin
        up_state = 0;
        down_state = 0;
    end

    V(up)   <+ transition(down_state ? vdd : 0.0, td, trf, trf);
    V(down) <+ transition(up_state ? vdd : 0.0, td, trf, trf);
end

endmodule
