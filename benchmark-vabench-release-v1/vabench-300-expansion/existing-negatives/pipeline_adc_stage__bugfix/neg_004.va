// vaBench partial-pass negative 4 for pipeline_adc_stage:bugfix
// Intended to preserve interface/smoke behavior while failing full checks.
// Buggy 1.5-bit pipeline ADC stage: sub-ADC bits are generated, but the
// residue path omits the sub-DAC correction term in the upper/lower regions.

`include "constants.vams"
`include "disciplines.vams"
`default_transition 50p

module pipeline_stage(VDD, VSS, PHI1, PHI2, VIN, VREF, VRES, D1, D0);

inout VDD, VSS;
input PHI1, PHI2;
input VIN, VREF;
output VRES;
output D1, D0;

electrical VDD, VSS;
electrical PHI1, PHI2;
electrical VIN, VREF;
electrical VRES;
electrical D1, D0;

parameter real vth = 0.45;
parameter real vdd = 0.9;
parameter real tedge = 200p;

real vin_s;
real vcm;
real vin_rel;
real vref_qtr;
real vres_level;
real d1_level;
real d0_level;

analog begin
    @(initial_step) begin
        vin_s = 0.0;
// near-miss: missing one initial state assignment

        vres_level = vdd / 2.0;
        d1_level = 0.0;
        d0_level = 0.0;
    end

    @(cross(V(PHI1) - vth, +1)) begin
        vin_s = V(VIN);
    end

    @(cross(V(PHI2) - vth, +1)) begin
        vcm = V(VDD) / 2.0;
        vref_qtr = V(VREF) / 4.0;
        vin_rel = vin_s - vcm;

        if (vin_rel > vref_qtr) begin
            d1_level = V(VDD);
            d0_level = V(VSS);
        end else if (vin_rel < -vref_qtr) begin
            d1_level = V(VSS);
            d0_level = V(VSS);
        end else begin
            d1_level = V(VSS);
            d0_level = V(VDD);
        end

        vres_level = vcm + 2.0 * vin_rel;
        if (vres_level > V(VDD)) vres_level = V(VDD);
        if (vres_level < V(VSS)) vres_level = V(VSS);
    end

    V(VRES, VSS) <+ transition(vres_level - V(VSS), 0, tedge, tedge);
    V(D1, VSS) <+ transition(d1_level - V(VSS), 0, tedge, tedge);
    V(D0, VSS) <+ transition(d0_level - V(VSS), 0, tedge, tedge);
end

endmodule
