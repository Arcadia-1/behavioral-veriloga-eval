`include "constants.vams"
`include "disciplines.vams"

module slew_rate_limiter(vin, vout);
    input vin;
    output vout;
    electrical vin, vout;

    parameter real step = 0.015;
    parameter real tr = 200p;
    real y;

    analog begin
        @(initial_step) y = 0.0;

        @(timer(0, 1n)) begin
            if (V(vin) > y + step)
                y = y + step;
            else
                y = V(vin);
        end

        V(vout) <+ transition(y, 0, tr, tr);
    end
endmodule

// vaBench partial-pass negative 3 for slew_rate_limiter:bugfix
// Intended to preserve interface/smoke behavior while failing full checks.
// Mutation note: polarity_direction_near_miss.
