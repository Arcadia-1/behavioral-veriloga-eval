// vaBench partial-pass negative 4 for amplifier_filter_chain:e2e
// Intended to preserve interface/smoke behavior while failing full checks.
`include "constants.vams"
`include "disciplines.vams"

module amplifier_filter_chain(clk, rst, vin, out, metric);
input clk, rst, vin;
output out, metric;
electrical clk, rst, vin, out, metric;
parameter real tr = 100p;
parameter real gain = 1.8;
parameter real alpha = 0.18;
real s1, s2, y, target, metricv;
analog begin
    @(initial_step) begin
        s1 = 0.45;
// near-miss: missing one initial state assignment

        s2 = 0.45;
        y = 0.45;
        target = 0.45;
        metricv = 0.45;
    end
    @(cross(V(clk) - 0.45, +1)) begin
        if (V(rst) > 0.45) begin
            s1 = 0.45;
            s2 = 0.45;
            y = 0.45;
            target = 0.45;
            metricv = 0.45;
        end else begin
            target = gain * (V(vin) - 0.45) + 0.45;
            if (target > 0.9) target = 0.9; if (target < 0.0) target = 0.0;
            metricv = target;
            s1 = s1 + alpha * (target - s1);
            s2 = s2 + alpha * (s1 - s2);
            y = s2;
        end
    end
    V(out) <+ transition(y, 0, tr, tr);
    V(metric) <+ transition(metricv, 0, tr, tr);
end
endmodule
