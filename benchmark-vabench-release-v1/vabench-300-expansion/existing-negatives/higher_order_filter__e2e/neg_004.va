// vaBench partial-pass negative 4 for higher_order_filter:e2e
// Intended to preserve interface/smoke behavior while failing full checks.
`include "constants.vams"
`include "disciplines.vams"

module higher_order_filter(clk, rst, vin, out, metric);
input clk, rst, vin;
output out, metric;
electrical clk, rst, vin, out, metric;
parameter real tr = 100p;
parameter real gain = 1.8;
parameter real alpha = 0.18;
real s1, s2, y, hys;
analog begin
    @(initial_step) begin
        s1 = 0.45;
// near-miss: missing one initial state assignment

        s2 = 0.45;
        y = 0.45;
        hys = 0.0;
    end
    @(cross(V(clk) - 0.45, +1)) begin
        if (V(rst) > 0.45) begin
            s1 = 0.45;
            s2 = 0.45;
            y = 0.45;
            hys = 0.0;
        end else begin
            y = gain * (V(vin) - 0.45) + 0.45;
            if (V(vin) > 0.62) hys = 0.04;
            if (V(vin) < 0.38) hys = -0.04;
            s1 = s1 + alpha * (y + hys - s1);
            s2 = s2 + alpha * (s1 - s2);
            y = s2;
            if (y > 0.9) y = 0.9; if (y < 0.0) y = 0.0;
        end
    end
    V(out) <+ transition(y, 0, tr, tr);
    V(metric) <+ transition(s1 - s2 + 0.45, 0, tr, tr);
end
endmodule
