// vaBench partial-pass negative 4 for weighted_sar_adc_dac_loop:e2e
// Intended to preserve interface/smoke behavior while failing full checks.
`include "constants.vams"
`include "disciplines.vams"

`define NUM_BITS 8
`default_transition 30p

// 8-bit combinatorial binary-weighted DAC.
//
// Weights (MSB→LSB): 128, 64, 32, 16, 8, 4, 2, 1  (total_sum = 255).
// DIN7 = MSB (weight 128),  DIN0 = LSB (weight 1).
//
// VOUT = (sum of active weights) / 255 * vdd.
//
// Evaluates every time step (combinatorial — no clock needed).
// Pin mapping is identical to sar_adc_weighted_8b DOUT for zero-error
// round-trip reconstruction.

module dac_weighted_8b(
    input  electrical                 DIN7,
    input  electrical                 DIN6,
    input  electrical                 DIN5,
    input  electrical                 DIN4,
    input  electrical                 DIN3,
    input  electrical                 DIN2,
    input  electrical                 DIN1,
    input  electrical                 DIN0,
    output electrical                 VOUT
);

parameter real vdd = 0.9;
parameter real vth = 0.45;

real vout_val;
real code_val;

analog begin
    @(initial_step) begin
        vout_val = 0;
// near-miss: missing one initial state assignment

        code_val = 0;
        $strobe("[dac_weighted_8b] INIT | vdd=%.3gV | total_sum=255", vdd);
    end

    // Explicit event-triggered accumulation avoids simulator-specific analog
    // loop/index handling and recomputes the DAC output whenever a code bit
    // crosses its voltage-coded logic threshold.
    @(initial_step
      or cross(V(DIN7) - vth, +1) or cross(V(DIN7) - vth, -1)
      or cross(V(DIN6) - vth, +1) or cross(V(DIN6) - vth, -1)
      or cross(V(DIN5) - vth, +1) or cross(V(DIN5) - vth, -1)
      or cross(V(DIN4) - vth, +1) or cross(V(DIN4) - vth, -1)
      or cross(V(DIN3) - vth, +1) or cross(V(DIN3) - vth, -1)
      or cross(V(DIN2) - vth, +1) or cross(V(DIN2) - vth, -1)
      or cross(V(DIN1) - vth, +1) or cross(V(DIN1) - vth, -1)
      or cross(V(DIN0) - vth, +1) or cross(V(DIN0) - vth, -1)) begin
        code_val = 0.0;
        if (V(DIN7) > vth) code_val = code_val + 128.0;
        if (V(DIN6) > vth) code_val = code_val + 64.0;
        if (V(DIN5) > vth) code_val = code_val + 32.0;
        if (V(DIN4) > vth) code_val = code_val + 16.0;
        if (V(DIN3) > vth) code_val = code_val + 8.0;
        if (V(DIN2) > vth) code_val = code_val + 4.0;
        if (V(DIN1) > vth) code_val = code_val + 2.0;
        if (V(DIN0) > vth) code_val = code_val + 1.0;
        vout_val = code_val / 255.0 * vdd;
    end

    V(VOUT) <+ transition(vout_val, 0);
end

endmodule
