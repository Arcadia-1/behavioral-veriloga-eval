// vaBench partial-pass negative 4 for iq_downconversion_chain:e2e
// Intended to preserve interface/smoke behavior while failing full checks.
`include "constants.vams"
`include "disciplines.vams"

module iq_downconversion_chain(clk, rst, vin, out, metric);
input clk, rst, vin;
output out, metric;
electrical clk, rst, vin, out, metric;
parameter real tr = 80p;
parameter real vth = 0.45;
real basev, iv, qv, icoef, qcoef;
integer phase;
analog begin
    @(initial_step) begin
        phase = 3;
// near-miss: missing one initial state assignment

        iv = 0.45;
        qv = 0.45;
    end
    @(cross(V(clk) - vth, +1)) begin
        if (V(rst) > vth) begin
            phase = 3;
            iv = 0.45;
            qv = 0.45;
        end else begin
            phase = phase + 1;
            if (phase > 3) phase = 0;
            if (phase == 0) icoef = 1.0;
            else if (phase == 1) icoef = 0.0;
            else if (phase == 2) icoef = -1.0;
            else icoef = 0.0;
            if (phase == 0) qcoef = 0.0;
            else if (phase == 1) qcoef = 1.0;
            else if (phase == 2) qcoef = 0.0;
            else qcoef = -1.0;
            basev = V(vin) - 0.45;
            iv = 0.45 + 1.25 * basev * icoef;
            qv = 0.45 + 1.25 * basev * qcoef;
            if (iv > 0.88) iv = 0.88;
            if (iv < 0.02) iv = 0.02;
            if (qv > 0.88) qv = 0.88;
            if (qv < 0.02) qv = 0.02;
        end
    end
    V(out) <+ transition(iv, 0, tr, tr);
    V(metric) <+ transition(qv, 0, tr, tr);
end
endmodule
