`include "constants.vams"
`include "disciplines.vams"

module sample_hold_aperture_ref (
    inout electrical VDD,
    inout electrical VSS,
    input electrical clk,
    input electrical vin,
    output electrical vout
);
    parameter real vth = 0.45;
    parameter real taperture = 200p from [0:inf);
    parameter real tedge = 50p from (0:inf);

    real sampled;

    analog begin
        @(initial_step) sampled = V(vin);
        @(cross(V(clk) - vth, +1)) sampled = V(vin);
        V(vout) <+ transition(sampled, 0.0, tedge, tedge);
    end
endmodule

// vaBench partial-pass negative 3 for aperture_delay_track_hold:bugfix
// Intended to preserve interface/smoke behavior while failing full checks.
// Mutation note: polarity_direction_near_miss.
