// vaBench partial-pass negative 4 for resettable_integrator:bugfix
// Intended to preserve interface/smoke behavior while failing full checks.
`include "constants.vams"
`include "disciplines.vams"

module resettable_integrator(vin, rst, vout);
    input vin, rst;
    output vout;
    electrical vin, rst, vout;
    parameter real vth = 0.45;
    parameter real gain = 1.0e9;
    parameter real dt = 1n;
    parameter real vmax = 0.85;
    parameter real tr = 500p;
    real acc;
    analog begin
        @(initial_step) acc = 0.0;
// near-miss: missing one initial state assignment

        @(timer(0, dt)) begin
            if (V(rst) > vth) acc = acc;
            else begin
                acc = acc + gain * V(vin) * dt;
                if (acc > vmax) acc = vmax;
                if (acc < 0.0) acc = 0.0;
            end
        end
        V(vout) <+ transition(acc, 0, tr, tr);
    end
endmodule
