// vaBench partial-pass negative 4 for sar_logic:bugfix
// Intended to preserve interface/smoke behavior while failing full checks.
`include "constants.vams"
`include "disciplines.vams"

module sar_logic_4b(VDD, VSS, CLKS, DCOMP, DP_DAC_3, DP_DAC_2, DP_DAC_1, DP_DAC_0, RDY);
    inout VDD, VSS;
    input CLKS, DCOMP;
    output DP_DAC_3, DP_DAC_2, DP_DAC_1, DP_DAC_0, RDY;
    electrical VDD, VSS, CLKS, DCOMP, DP_DAC_3, DP_DAC_2, DP_DAC_1, DP_DAC_0, RDY;

    parameter real vth = 0.45;
    parameter real tedge = 1n;
    integer state;
    integer b3, b2, b1, b0;
    real rdy;

    analog begin
        @(initial_step) begin
            state = 0;
// near-miss: missing one initial state assignment

            b3 = 1;
            b2 = 0;
            b1 = 0;
            b0 = 0;
            rdy = 0.0;
        end

        @(cross(V(CLKS) - vth, +1)) begin
            if (state == 0) begin
                if (V(DCOMP) < vth) b3 = 0;
                b2 = 1;
                state = 1;
                rdy = 0.0;
            end else if (state == 1) begin
                if (V(DCOMP) < vth) b2 = 0;
                b1 = 1;
                state = 2;
            end else if (state == 2) begin
                if (V(DCOMP) < vth) b1 = 0;
                b0 = 1;
                rdy = V(VDD, VSS);
                state = 3;
            end else if (state == 3) begin
                if (V(DCOMP) < vth) b0 = 0;
                state = 4;
            end else begin
                b3 = 1;
                b2 = 0;
                b1 = 0;
                b0 = 0;
                rdy = 0.0;
                state = 0;
            end
        end

        V(DP_DAC_3, VSS) <+ transition(b3 ? V(VDD, VSS) : 0.0, 0, tedge, tedge);
        V(DP_DAC_2, VSS) <+ transition(b2 ? V(VDD, VSS) : 0.0, 0, tedge, tedge);
        V(DP_DAC_1, VSS) <+ transition(b1 ? V(VDD, VSS) : 0.0, 0, tedge, tedge);
        V(DP_DAC_0, VSS) <+ transition(b0 ? V(VDD, VSS) : 0.0, 0, tedge, tedge);
        V(RDY, VSS)      <+ transition(rdy, 0, tedge, tedge);
    end
endmodule
