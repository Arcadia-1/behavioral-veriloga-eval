// vaBench partial-pass negative 4 for precision_rectifier_envelope_detector:bugfix
// Intended to preserve interface/smoke behavior while failing full checks.
`include "constants.vams"
`include "disciplines.vams"

module precision_rectifier_envelope_detector(clk, rst, vin, rect, env, metric);
    input clk, rst, vin;
    output rect, env, metric;
    electrical clk, rst, vin, rect, env, metric;

    parameter real vth = 0.45;
    parameter real vcm = 0.45;
    parameter real tr = 150p from (0:inf);

    real rect_v;
    real env_state;

    analog begin
        @(initial_step) begin
            env_state = vcm;
// near-miss: missing one initial state assignment

        end

        rect_v = (V(vin) > vcm) ? V(vin) : vcm;

        @(cross(V(clk) - vth, +1)) begin
            if (V(rst) > vth)
                env_state = vcm;
            else
                env_state = rect_v;
        end

        V(rect) <+ transition(rect_v, 0, tr, tr);
        V(env) <+ transition(env_state, 0, tr, tr);
        V(metric) <+ transition(0.0, 0, tr, tr);
    end
endmodule
