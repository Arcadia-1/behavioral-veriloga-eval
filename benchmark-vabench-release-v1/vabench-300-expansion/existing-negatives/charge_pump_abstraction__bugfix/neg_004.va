// vaBench partial-pass negative 4 for charge_pump_abstraction:bugfix
// Intended to preserve interface/smoke behavior while failing full checks.
`include "constants.vams"
`include "disciplines.vams"

module charge_pump_abstraction(clk, rst, up, dn, vctrl, metric);
input clk, rst, up, dn;
output vctrl, metric;
electrical clk, rst, up, dn, vctrl, metric;
parameter real tr = 100p;
parameter real vth = 0.45;
parameter real step = 0.06;
parameter real vmin = 0.05;
parameter real vmax = 0.85;
real ctrl, metricv;
analog begin
    @(initial_step) begin
        ctrl = 0.45;
// near-miss: missing one initial state assignment

        metricv = 0.45;
    end
    @(cross(V(clk) - vth, +1)) begin
        if (V(rst) > vth) begin
            ctrl = 0.45;
            metricv = 0.45;
        end else if (V(up) > vth && V(dn) <= vth) begin
            ctrl = ctrl - step;
            metricv = 0.75;
        end else if (V(dn) > vth && V(up) <= vth) begin
            ctrl = ctrl + step;
            metricv = 0.15;
        end else begin
            metricv = 0.45;
        end
        if (ctrl > vmax) ctrl = vmax;
        if (ctrl < vmin) ctrl = vmin;
    end
    V(vctrl) <+ transition(ctrl, 0, tr, tr);
    V(metric) <+ transition(metricv, 0, tr, tr);
end
endmodule
