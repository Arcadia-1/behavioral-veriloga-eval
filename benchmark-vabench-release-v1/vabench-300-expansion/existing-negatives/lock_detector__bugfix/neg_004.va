// vaBench partial-pass negative 4 for lock_detector:bugfix
// Intended to preserve interface/smoke behavior while failing full checks.
`include "constants.vams"
`include "disciplines.vams"

module lock_detector(ref_clk, fb_clk, rst_n, lock);
    input ref_clk, fb_clk, rst_n;
    output lock;
    electrical ref_clk, fb_clk, rst_n, lock;
    parameter real vth = 0.45;
    parameter real vdd = 0.9;
    parameter real tol = 2n;
    parameter integer need = 3;
    parameter real tr = 500p;
    real last_fb;
    integer streak;
    integer locked;
    analog begin
        @(initial_step) begin last_fb=-1.0;
// near-miss: missing one initial state assignment
 streak=0; locked=0; end
        @(cross(V(rst_n)-vth,-1)) begin streak=0; locked=0; last_fb=-1.0; end
        @(cross(V(fb_clk)-vth,+1)) last_fb = $abstime;
        @(cross(V(ref_clk)-vth,+1)) begin
            if (V(rst_n)<vth) begin streak=0; locked=0; end
            else begin
                if (last_fb>=0.0 && abs($abstime-last_fb) <= tol) streak=streak+1; else streak=0;
                if (streak>need) locked=1;
            end
        end
        V(lock) <+ transition(locked ? vdd : 0.0, 0, tr, tr);
    end
endmodule
