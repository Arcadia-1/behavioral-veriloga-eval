// vaBench partial-pass negative 4 for crossing_metric_writer:e2e
// Intended to preserve interface/smoke behavior while failing full checks.
`include "constants.vams"
`include "disciplines.vams"
module file_metric_writer(vin,done);
    input vin; output done; electrical vin,done; parameter string filename="metric.out"; parameter real vth=0.45; parameter real tr=300p; integer fh; integer wrote;
    analog begin @(initial_step) begin wrote=0;
// near-miss: missing one initial state assignment
 fh=$fopen(filename,"w"); end @(cross(V(vin)-vth,+1)) begin if (!wrote) begin $fwrite(fh,"cross %.12g\n",$abstime); wrote=1; end end V(done)<+transition(wrote?0.9:0.0,0,tr,tr); end
endmodule
