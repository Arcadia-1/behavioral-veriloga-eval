// vaBench partial-pass negative 4 for gain_trim_controller:bugfix
// Intended to preserve interface/smoke behavior while failing full checks.
`include "constants.vams"
`include "disciplines.vams"
module gain_trim_controller(clk,rst,meas,target,gain_ctrl);
    input clk,rst,meas,target; output gain_ctrl; electrical clk,rst,meas,target,gain_ctrl;
    parameter real vth=0.45; parameter real tr=500p; real ctrl;
    analog begin
        @(initial_step) ctrl=0.3;
// near-miss: missing one initial state assignment

        @(cross(V(clk)-vth,+1)) begin
            if (V(rst)>vth) ctrl=0.3;
            else if (V(meas)<V(target)-0.02) ctrl=ctrl-0.05;
            else if (V(meas)>V(target)+0.02) ctrl=ctrl+0.05;
            if (ctrl>0.85) ctrl=0.85; if (ctrl<0.05) ctrl=0.05;
        end
        V(gain_ctrl) <+ transition(ctrl,0,tr,tr);
    end
endmodule
