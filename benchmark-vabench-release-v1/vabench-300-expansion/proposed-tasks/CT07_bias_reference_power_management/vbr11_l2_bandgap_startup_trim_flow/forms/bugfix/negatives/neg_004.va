`include "constants.vams"
`include "disciplines.vams"

module bandgap_startup_trim(in, clk, rst, out, metric);
  input in, clk, rst;
  output out, metric;
  electrical in, clk, rst, out, metric;
  // vaBench v1.1 task-specific template: negative variant: state_reset_near_miss
  // Target behavior: bandgap startup and trim loop that ramps a reference toward a bounded settled target
  parameter real vth = 0.5;
  real state;
  real aux;
  real sample;
  real integ;
  real feedback;
  real bitval;
  real metric_value;
  real target;
  integer phase;
  integer acc;
  integer count;
  integer ones;

  analog begin
    @(initial_step) begin
      state = 0.0;
      aux = 0.0;
      sample = 0.0;
      integ = 0.0;
      feedback = 0.0;
      bitval = 0.0;
      metric_value = 0.0;
      target = 0.0;
      phase = -1;
      acc = 0;
      count = 0;
      ones = 0;
    end
    @(cross(V(rst) - vth, +1)) begin
      // near-miss: state intentionally retained across reset
      // near-miss: auxiliary state intentionally retained across reset
      sample = 0.0;
      integ = 0.0;
      feedback = 0.0;
      bitval = 0.0;
      metric_value = 0.0;
      target = 0.0;
      phase = -1;
      acc = 0;
      count = 0;
      ones = 0;
    end

    @(cross(V(clk) - vth, +1)) begin
      target = 1.18 + 0.08;
      state = state + 0.10 * (target - state);
      if (state > 1.08 && state < 1.28) aux = aux + 0.08; else aux = aux * 0.8;
      if (aux > 1.0) aux = 1.0;
      count = count + 1;
      metric_value = aux * 0.0;
      // metric follows task-specific behavior
    end

    V(out) <+ transition(state, 0, 1n);
    V(metric) <+ transition(metric_value, 0, 1n);
  end
endmodule
