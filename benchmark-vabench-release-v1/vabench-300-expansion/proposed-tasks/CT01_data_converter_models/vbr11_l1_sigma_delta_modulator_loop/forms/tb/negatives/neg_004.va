`include "constants.vams"
`include "disciplines.vams"

module sigma_delta_modulator_loop(in, clk, rst, out, metric);
  input in, clk, rst;
  output out, metric;
  electrical in, clk, rst, out, metric;
  // vaBench v1.1 task-specific template: negative variant: state_reset_near_miss
  // Target behavior: first-order sigma-delta loop with clocked integrator, one-bit feedback DAC, and bit-density metric
  parameter real vth = 0.5;
  real state;
  real aux;
  real sample;
  real integ;
  real feedback;
  real bitval;
  real metric_value;
  real target;
  integer phase;
  integer acc;
  integer count;
  integer ones;

  analog begin
    @(initial_step) begin
      state = 0.0;
      aux = 0.0;
      sample = 0.0;
      integ = 0.0;
      feedback = 0.0;
      bitval = 0.0;
      metric_value = 0.0;
      target = 0.0;
      phase = -1;
      acc = 0;
      count = 0;
      ones = 0;
    end
    @(cross(V(rst) - vth, +1)) begin
      // near-miss: state intentionally retained across reset
      // near-miss: auxiliary state intentionally retained across reset
      sample = 0.0;
      integ = 0.0;
      feedback = 0.0;
      bitval = 0.0;
      metric_value = 0.0;
      target = 0.0;
      phase = -1;
      acc = 0;
      count = 0;
      ones = 0;
    end

    @(cross(V(clk) - vth, +1)) begin
      feedback = bitval > 0.5 ? 0.42 : -0.42;
      integ = integ + V(in) - (1.0) * feedback + 0.08;
      if (integ > 1.2) integ = 1.2;
      if (integ < -1.2) integ = -1.2;
      if (integ >= 0.0) bitval = 1.0; else bitval = 0.0;
      if (bitval > 0.5) ones = ones + 1;
      count = count + 1;
      state = bitval;
      aux = count > 0 ? (1.0 * ones) / count : 0.0;
      metric_value = aux * 0.0;
      // metric follows task-specific behavior
    end

    V(out) <+ transition(state, 0, 1n);
    V(metric) <+ transition(metric_value, 0, 1n);
  end
endmodule
