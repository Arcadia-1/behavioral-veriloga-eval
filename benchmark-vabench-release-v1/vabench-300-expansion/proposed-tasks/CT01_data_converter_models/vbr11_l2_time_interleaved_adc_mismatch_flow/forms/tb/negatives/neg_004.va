`include "constants.vams"
`include "disciplines.vams"

module time_interleaved_adc_mismatch(in, clk, rst, out, metric);
  input in, clk, rst;
  output out, metric;
  electrical in, clk, rst, out, metric;
  // vaBench v1.1 task-specific template: negative variant: state_reset_near_miss
  // Target behavior: four-lane time-interleaved ADC observation model with lane-dependent offset/gain mismatch
  parameter real vth = 0.5;
  real state;
  real aux;
  real sample;
  real integ;
  real feedback;
  real bitval;
  real metric_value;
  real target;
  integer phase;
  integer acc;
  integer count;
  integer ones;

  analog begin
    @(initial_step) begin
      state = 0.0;
      aux = 0.0;
      sample = 0.0;
      integ = 0.0;
      feedback = 0.0;
      bitval = 0.0;
      metric_value = 0.0;
      target = 0.0;
      phase = -1;
      acc = 0;
      count = 0;
      ones = 0;
    end
    @(cross(V(rst) - vth, +1)) begin
      // near-miss: state intentionally retained across reset
      // near-miss: auxiliary state intentionally retained across reset
      sample = 0.0;
      integ = 0.0;
      feedback = 0.0;
      bitval = 0.0;
      metric_value = 0.0;
      target = 0.0;
      phase = -1;
      acc = 0;
      count = 0;
      ones = 0;
    end

    @(cross(V(clk) - vth, +1)) begin
      phase = phase + 1;
      if (phase > 3) phase = 0;
      if (phase == 0) begin
        state = (1.0) * (0.92 * V(in) - 0.055 + 0.08);
        aux = 0.06;
      end else if (phase == 1) begin
        state = (1.0) * (1.04 * V(in) + 0.025 + 0.08);
        aux = 0.35;
      end else if (phase == 2) begin
        state = (1.0) * (0.97 * V(in) + 0.065 + 0.08);
        aux = 0.68;
      end else begin
        state = (1.0) * (1.08 * V(in) - 0.020 + 0.08);
        aux = 0.94;
      end
      count = count + 1;
      metric_value = aux * 0.0;
      // metric follows task-specific behavior
    end

    V(out) <+ transition(state, 0, 1n);
    V(metric) <+ transition(metric_value, 0, 1n);
  end
endmodule
