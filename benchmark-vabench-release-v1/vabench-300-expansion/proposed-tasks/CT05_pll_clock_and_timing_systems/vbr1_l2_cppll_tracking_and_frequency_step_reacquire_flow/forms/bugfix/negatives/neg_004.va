// vaBench partial-pass negative 4 for cppll_tracking_frequency_step_reacquire:bugfix
// Intended to preserve interface/smoke behavior while failing full checks.
`include "constants.vams"
`include "disciplines.vams"

module cppll_tracking_frequency_step_reacquire(in, clk, rst, out, metric);
  input in, clk, rst;
  output out, metric;
  electrical in, clk, rst, out, metric;
  parameter real vth = 0.5;
  parameter real gain = 0.85;
  parameter real bias = 0.0;
  real state;
  integer count;

  analog begin
    @(initial_step) begin
      state = 0.0;
// near-miss: missing one initial state assignment

      count = 0;
    end
    @(cross(V(rst) - vth, +1)) begin
      state = 0.0;
      count = 0;
    end
    @(cross(V(clk) - vth, +1)) begin
      state = gain * state + V(in) + bias;
      if (state > 1.0) state = 1.0;
      if (state < -1.0) state = -1.0;
      count = count + 1;
    end
    V(out) <+ transition(state, 0, 1n);
    V(metric) <+ transition(count > 0 ? state / count : 0.0, 0, 1n);
  end
endmodule
