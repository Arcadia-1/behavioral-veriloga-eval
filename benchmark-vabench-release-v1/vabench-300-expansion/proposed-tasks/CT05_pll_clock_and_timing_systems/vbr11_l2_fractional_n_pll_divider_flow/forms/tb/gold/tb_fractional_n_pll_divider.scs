simulator lang=spectre
global 0
ahdl_include "fractional_n_pll_divider.va"
Vclk (clk 0) vsource type=pulse val0=0 val1=1 delay=0 rise=1n fall=1n width=5n period=10n
Vrst (rst 0) vsource type=pulse val0=0 val1=1 delay=0 rise=1n fall=1n width=10n period=200n
Vin (in 0) vsource type=sine sinedc=0 ampl=0.6 freq=10Meg
Xdut (in clk rst out metric) fractional_n_pll_divider
tran tran stop=100n maxstep=500p
