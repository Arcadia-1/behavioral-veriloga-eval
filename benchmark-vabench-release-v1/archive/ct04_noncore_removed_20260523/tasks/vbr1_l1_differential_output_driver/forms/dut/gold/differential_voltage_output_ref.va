`include "constants.vams"
`include "disciplines.vams"

module differential_voltage_output_ref (
    inout  electrical VDD,
    inout  electrical VSS,
    input  electrical din,
    input  electrical en,
    output electrical outp,
    output electrical outn
);

parameter real vcm = 0.45 from [0:inf);
parameter real vod = 0.4 from [0:inf);
parameter real vth = 0.45;
parameter real tedge = 60p from (0:inf);

real diff_target;
real outp_target;
real outn_target;
real vdd_now;
real vss_now;

analog begin
    vdd_now = V(VDD, VSS);
    vss_now = 0.0;

    if (V(en, VSS) > vth) begin
        diff_target = (V(din, VSS) > vth) ? vod : -vod;
    end else begin
        diff_target = 0.0;
    end

    outp_target = vcm + 0.5 * diff_target;
    outn_target = vcm - 0.5 * diff_target;

    if (outp_target > vdd_now) outp_target = vdd_now;
    if (outp_target < vss_now) outp_target = vss_now;
    if (outn_target > vdd_now) outn_target = vdd_now;
    if (outn_target < vss_now) outn_target = vss_now;

    V(outp, VSS) <+ transition(outp_target, 0.0, tedge, tedge);
    V(outn, VSS) <+ transition(outn_target, 0.0, tedge, tedge);
end

endmodule
