simulator lang=spectre
global 0

ahdl_include "cross_event_post_side_read.va"

Vin (vin 0) vsource type=pwl wave=[0 0 10n 0 11n 0.9 30n 0.9 31n 0 50n 0]

XDUT (vin state) cross_event_post_side_read

tran tran stop=50n maxstep=100p
save vin state
