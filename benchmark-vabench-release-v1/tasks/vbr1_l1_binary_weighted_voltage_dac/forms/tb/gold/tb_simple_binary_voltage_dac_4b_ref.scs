simulator lang=spectre
global 0

ahdl_include "simple_binary_voltage_dac_4b.va"

Vref (vref 0) vsource dc=0.9
Vss (vss 0) vsource dc=0
// Code samples at 10/30/.../150 ns are stable; transitions occur between samples.
Vb0 (code_0 0) vsource type=pwl wave=[0 0 19.5n 0 20n 0 39.5n 0 40n 0 59.5n 0 60n 0 79.5n 0 80n 0 99.5n 0 100n 0 119.5n 0 120n 0 139.5n 0 140n 0.9 160n 0.9]
Vb1 (code_1 0) vsource type=pwl wave=[0 0 19.5n 0 20n 0.9 39.5n 0.9 40n 0 59.5n 0 60n 0.9 79.5n 0.9 80n 0 99.5n 0 100n 0.9 119.5n 0.9 120n 0 139.5n 0 140n 0.9 160n 0.9]
Vb2 (code_2 0) vsource type=pwl wave=[0 0 19.5n 0 20n 0 39.5n 0 40n 0.9 59.5n 0.9 60n 0.9 79.5n 0.9 80n 0 99.5n 0 100n 0 119.5n 0 120n 0.9 139.5n 0.9 140n 0.9 160n 0.9]
Vb3 (code_3 0) vsource type=pwl wave=[0 0 19.5n 0 20n 0 39.5n 0 40n 0 59.5n 0 60n 0 79.5n 0 80n 0.9 99.5n 0.9 100n 0.9 119.5n 0.9 120n 0.9 139.5n 0.9 140n 0.9 160n 0.9]

XDUT (code_0 code_1 code_2 code_3 vref vss aout) simple_binary_voltage_dac_4b

tran tran stop=165n maxstep=500p
save code_0 code_1 code_2 code_3 aout
