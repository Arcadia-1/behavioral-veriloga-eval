simulator lang=spectre
global 0

ahdl_include "adc_dac_source_sweep_flow.va"

Vclk (clk 0) vsource type=pulse val0=0 val1=0.9 period=2n width=1n rise=50p fall=50p
Vrst (rst 0) vsource type=pwl wave=[0 0.9 2n 0.9 2.1n 0 80n 0]
Vvin (vin 0) vsource type=pwl wave=[0 0.05 10n 0.1 30n 0.7 60n 0.35 80n 0.85]
Vaux (aux 0) vsource dc=0.45

XDUT (clk rst vin aux out metric) adc_dac_source_sweep_flow

tran tran stop=80n maxstep=0.5n
save clk rst vin out metric
