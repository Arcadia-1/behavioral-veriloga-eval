`include "constants.vams"
`include "disciplines.vams"

module soft_hysteretic_limiter(clk, rst, vin, out, metric);
input clk, rst, vin;
output out, metric;
electrical clk, rst, vin, out, metric;
parameter real tr = 100p;
parameter real vlo = 0.15;
parameter real vhi = 0.75;
parameter real memory = 0.06;
real y, target, state, metric_state;
analog begin
    @(initial_step) begin
        y = 0.45;
        state = 0.0;
        metric_state = 0.45;
    end
    @(cross(V(clk) - 0.45, +1)) begin
        if (V(rst) > 0.45) begin
            y = 0.45;
            state = 0.0;
            metric_state = 0.45;
        end else begin
            if (V(vin) > 0.62) state = 1.0;
            if (V(vin) < 0.38) state = -1.0;
            target = V(vin) + memory * state;
            if (target > vhi) target = vhi + 0.25 * (target - vhi);
            if (target < vlo) target = vlo + 0.25 * (target - vlo);
            if (target > 0.9) target = 0.9;
            if (target < 0.0) target = 0.0;
            y = target;
            metric_state = 0.45 + 0.20 * state;
        end
    end
    V(out) <+ transition(y, 0, tr, tr);
    V(metric) <+ transition(metric_state, 0, tr, tr);
end
endmodule
