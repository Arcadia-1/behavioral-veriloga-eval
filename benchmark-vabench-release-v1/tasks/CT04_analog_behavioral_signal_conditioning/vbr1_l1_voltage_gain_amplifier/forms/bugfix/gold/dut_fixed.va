`include "constants.vams"
`include "disciplines.vams"

module voltage_gain_amplifier(clk, rst, vin, out, metric);
input clk, rst, vin;
output out, metric;
electrical clk, rst, vin, out, metric;
parameter real tr = 100p;
parameter real gain = 1.8;
parameter real vcm = 0.45;
real y, target, sat_flag;
analog begin
    @(initial_step) begin
        y = vcm;
        sat_flag = 0.0;
    end
    @(cross(V(clk) - 0.45, +1)) begin
        if (V(rst) > 0.45) begin
            y = vcm;
            sat_flag = 0.0;
        end else begin
            target = gain * (V(vin) - vcm) + vcm;
            sat_flag = 0.0;
            if (target > 0.9) begin
                y = 0.9;
                sat_flag = 0.9;
            end else if (target < 0.0) begin
                y = 0.0;
                sat_flag = 0.9;
            end else begin
                y = target;
            end
        end
    end
    V(out) <+ transition(y, 0, tr, tr);
    V(metric) <+ transition(sat_flag, 0, tr, tr);
end
endmodule
