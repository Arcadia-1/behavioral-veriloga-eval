simulator lang=spectre
global 0

Vvdd (VDD 0) vsource dc=0.9 type=dc
Vvss (VSS 0) vsource dc=0.0 type=dc
Vdin (din 0) vsource type=pwl wave=[0 0 30n 0 32n 0.9 52n 0.9 54n 0.9 70n 0.9 72n 0 100n 0]
Ven (en 0) vsource type=pwl wave=[0 0 10n 0 12n 0.9 52n 0.9 54n 0 70n 0 72n 0.9 100n 0.9]

IDUT (VDD VSS din en outp outn) differential_voltage_output_ref \
    vcm=0.45 vod=0.4 vth=0.45 tedge=60p

simulatorOptions options reltol=1e-4 vabstol=1e-6 iabstol=1e-12 temp=27 tnom=27 gmin=1e-12
tran tran stop=100n maxstep=100p errpreset=conservative
save din en outp outn

ahdl_include "./differential_voltage_output_ref.va"
