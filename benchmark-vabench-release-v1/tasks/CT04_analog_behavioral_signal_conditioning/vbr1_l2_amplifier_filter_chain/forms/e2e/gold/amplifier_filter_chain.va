`include "constants.vams"
`include "disciplines.vams"

module amplifier_filter_chain(clk, rst, vin, out, metric);
input clk, rst, vin;
output out, metric;
electrical clk, rst, vin, out, metric;
parameter real tr = 100p;
parameter real gain = 1.8;
parameter real alpha = 0.22;
parameter real vcm = 0.45;
real amp_target, filt;
analog begin
    @(initial_step) begin
        amp_target = vcm;
        filt = vcm;
    end
    @(cross(V(clk) - 0.45, +1)) begin
        if (V(rst) > 0.45) begin
            amp_target = vcm;
            filt = vcm;
        end else begin
            amp_target = gain * (V(vin) - vcm) + vcm;
            if (amp_target > 0.9) amp_target = 0.9;
            if (amp_target < 0.0) amp_target = 0.0;
            filt = filt + alpha * (amp_target - filt);
        end
    end
    V(out) <+ transition(filt, 0, tr, tr);
    V(metric) <+ transition(amp_target, 0, tr, tr);
end
endmodule
