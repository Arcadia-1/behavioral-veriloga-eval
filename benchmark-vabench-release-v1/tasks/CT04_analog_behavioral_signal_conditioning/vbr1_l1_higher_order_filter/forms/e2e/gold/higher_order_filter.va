`include "constants.vams"
`include "disciplines.vams"

module higher_order_filter(clk, rst, vin, out, metric);
input clk, rst, vin;
output out, metric;
electrical clk, rst, vin, out, metric;
parameter real tr = 100p;
parameter real alpha1 = 0.30;
parameter real alpha2 = 0.18;
real s1, s2, err_metric;
analog begin
    @(initial_step) begin
        s1 = 0.45;
        s2 = 0.45;
        err_metric = 0.45;
    end
    @(cross(V(clk) - 0.45, +1)) begin
        if (V(rst) > 0.45) begin
            s1 = 0.45;
            s2 = 0.45;
            err_metric = 0.45;
        end else begin
            s1 = s1 + alpha1 * (V(vin) - s1);
            s2 = s2 + alpha2 * (s1 - s2);
            err_metric = 0.45 + (s1 - s2);
            if (err_metric > 0.9) err_metric = 0.9;
            if (err_metric < 0.0) err_metric = 0.0;
        end
    end
    V(out) <+ transition(s2, 0, tr, tr);
    V(metric) <+ transition(err_metric, 0, tr, tr);
end
endmodule
