`include "constants.vams"
`include "disciplines.vams"

module adc_dac_source_sweep_flow(clk, rst, vin, aux, out, metric);
input clk, rst, vin, aux;
output out, metric;
electrical clk, rst, vin, aux, out, metric;
parameter real tr = 100p;
real sample, code, recon, metricv;
integer q;
analog begin
    @(initial_step) begin
        sample = 0.0;
        code = 0.0;
        recon = 0.0;
        metricv = 0.0;
    end
    @(cross(V(clk) - 0.45, +1)) begin
        if (V(rst) > 0.45) begin
            sample = 0.0;
            code = 0.0;
            recon = 0.0;
            metricv = 0.0;
        end else begin
            sample = V(vin);
            q = 0;
            if (sample > 0.9) q = 15;
            else if (sample > 0.0) q = sample / 0.9 * 15.0 + 0.5;
            code = q / 15.0;
            recon = 0.9 * code;
            metricv = (sample > 0.25 && sample < 0.65) ? 0.9 : 0.0;
        end
    end
    V(out) <+ transition(recon, 0, tr, tr);
    V(metric) <+ transition(metricv, 0, tr, tr);
end
endmodule
