simulator lang=spectre
global 0

ahdl_include "barrel_pointer_window.va"

Vclk (clk 0) vsource type=pulse val0=0 val1=0.9 delay=10n rise=200p fall=200p width=5n period=20n
Vrst (rst_n 0) vsource type=pwl wave=[0 0 8n 0 9n 0.9 130n 0.9]

XDUT (clk rst_n win0 win1 win2 win3) barrel_pointer_window

tran tran stop=130n maxstep=500p
save clk rst_n win0 win1 win2 win3
