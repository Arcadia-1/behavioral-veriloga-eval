simulator lang=spectre
global 0

ahdl_include "rotating_element_selector.va"

Vclk (clk 0) vsource type=pulse val0=0 val1=0.9 delay=10n rise=200p fall=200p width=5n period=20n
Vrst (rst_n 0) vsource type=pwl wave=[0 0 8n 0 9n 0.9 130n 0.9]

XDUT (clk rst_n sel0 sel1 sel2 sel3) rotating_element_selector

tran tran stop=130n maxstep=500p
save clk rst_n sel0 sel1 sel2 sel3
