`include "constants.vams"
`include "disciplines.vams"

module charge_pump_abstraction(clk, rst, vin, out, metric);
input clk, rst, vin;
output out, metric;
electrical clk, rst, vin, out, metric;
parameter real tr = 100p;
parameter real deadband = 0.05;
real state, step, errv, metricv;
analog begin
    @(initial_step) begin
        state = 0.45;
        step = 0.08;
        metricv = 0.45;
    end
    @(cross(V(clk) - 0.45, +1)) begin
        errv = V(vin) - 0.45;
        if (V(rst) > 0.45) begin
            state = 0.45;
            metricv = 0.45;
        end else if (errv > deadband) begin
            state = state + step;
            metricv = 0.75;
        end else if (errv < -deadband) begin
            state = state - step;
            metricv = 0.15;
        end else begin
            metricv = 0.45;
        end
        if (state > 0.85) state = 0.85;
        if (state < 0.05) state = 0.05;
    end
    V(out) <+ transition(state, 0, tr, tr);
    V(metric) <+ transition(metricv, 0, tr, tr);
end
endmodule
