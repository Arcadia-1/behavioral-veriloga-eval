`include "constants.vams"
`include "disciplines.vams"

module conversion_event_controller (
    inout electrical vdd,
    inout electrical vss,
    input electrical rst,
    input electrical start,
    input electrical cmp_done,
    output electrical sample_en,
    output electrical compare_en,
    output electrical readout_en,
    output electrical done,
    output electrical state_mon
);
    parameter real vth = 0.45;
    parameter real trf = 80p;
    parameter real sample_time = 12n;
    parameter real compare_timeout = 28n;
    parameter real readout_time = 16n;
    parameter real done_time = 8n;

    integer state;
    real sample_q;
    real compare_q;
    real readout_q;
    real done_q;
    real t_sample_done;
    real t_compare_timeout;
    real t_readout_done;
    real t_done_clear;

    analog begin
        @(initial_step) begin
            state = 0;
            sample_q = 0.0;
            compare_q = 0.0;
            readout_q = 0.0;
            done_q = 0.0;
            t_sample_done = 1.0;
            t_compare_timeout = 1.0;
            t_readout_done = 1.0;
            t_done_clear = 1.0;
        end

        @(cross(V(rst, vss) - vth, +1)) begin
            state = 0;
            sample_q = 0.0;
            compare_q = 0.0;
            readout_q = 0.0;
            done_q = 0.0;
            t_sample_done = 1.0;
            t_compare_timeout = 1.0;
            t_readout_done = 1.0;
            t_done_clear = 1.0;
        end

        @(cross(V(start, vss) - vth, +1)) begin
            if ((V(rst, vss) <= vth) && ((state == 0) || (state == 4))) begin
                state = 1;
                sample_q = V(vdd, vss);
                compare_q = 0.0;
                readout_q = 0.0;
                done_q = 0.0;
                t_sample_done = $abstime + sample_time;
                t_compare_timeout = 1.0;
                t_readout_done = 1.0;
                t_done_clear = 1.0;
            end
        end

        @(timer(t_sample_done)) begin
            if ((state == 1) && (V(rst, vss) <= vth)) begin
                state = 2;
                sample_q = 0.0;
                compare_q = V(vdd, vss);
                readout_q = 0.0;
                done_q = 0.0;
                t_sample_done = 1.0;
                t_compare_timeout = $abstime + compare_timeout;
            end
        end

        @(cross(V(cmp_done, vss) - vth, +1)) begin
            if ((state == 2) && (V(rst, vss) <= vth)) begin
                state = 3;
                sample_q = 0.0;
                compare_q = 0.0;
                readout_q = V(vdd, vss);
                done_q = 0.0;
                t_compare_timeout = 1.0;
                t_readout_done = $abstime + readout_time;
            end
        end

        @(timer(t_compare_timeout)) begin
            if ((state == 2) && (V(rst, vss) <= vth)) begin
                state = 3;
                sample_q = 0.0;
                compare_q = 0.0;
                readout_q = V(vdd, vss);
                done_q = 0.0;
                t_compare_timeout = 1.0;
                t_readout_done = $abstime + readout_time;
            end
        end

        @(timer(t_readout_done)) begin
            if ((state == 3) && (V(rst, vss) <= vth)) begin
                state = 4;
                sample_q = 0.0;
                compare_q = 0.0;
                readout_q = 0.0;
                done_q = V(vdd, vss);
                t_readout_done = 1.0;
                t_done_clear = $abstime + done_time;
            end
        end

        @(timer(t_done_clear)) begin
            if (state == 4) begin
                state = 0;
                done_q = 0.0;
                t_done_clear = 1.0;
            end
        end

        V(sample_en, vss) <+ transition(sample_q, 0, trf, trf);
        V(compare_en, vss) <+ transition(compare_q, 0, trf, trf);
        V(readout_en, vss) <+ transition(readout_q, 0, trf, trf);
        V(done, vss) <+ transition(done_q, 0, trf, trf);
        V(state_mon, vss) <+ transition((state / 4.0) * V(vdd, vss), 0, trf, trf);
    end
endmodule
