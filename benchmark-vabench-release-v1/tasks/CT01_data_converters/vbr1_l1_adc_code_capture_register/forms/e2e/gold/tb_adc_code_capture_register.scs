simulator lang=spectre
global 0

ahdl_include "adc_code_capture_register.va"

Vvdd (vdd 0) vsource dc=0.9
Vvss (vss 0) vsource dc=0
Vclk (clk 0) vsource type=pulse val0=0 val1=0.9 delay=5n rise=100p fall=100p width=4.8n period=10n
Vload (load 0) vsource type=pwl wave=[0 0 18n 0 19n 0.9 25n 0.9 26n 0 58n 0 59n 0.9 65n 0.9 66n 0 98n 0 99n 0.9 105n 0.9 106n 0]
Vlo (over_lo 0) vsource type=pwl wave=[0 0 130n 0]
Vhi (over_hi 0) vsource type=pwl wave=[0 0 98n 0 99n 0.9 105n 0.9 106n 0 130n 0]
Vd0 (din0 0) vsource type=pwl wave=[0 0.9 45n 0.9 46n 0 85n 0 86n 0.9 130n 0.9]
Vd1 (din1 0) vsource type=pwl wave=[0 0.9 45n 0.9 46n 0 85n 0 86n 0.9 130n 0.9]
Vd2 (din2 0) vsource type=pwl wave=[0 0 45n 0 46n 0.9 130n 0.9]
Vd3 (din3 0) vsource type=pwl wave=[0 0 45n 0 46n 0.9 130n 0.9]

XDUT (vdd vss clk load over_lo over_hi din3 din2 din1 din0 bit3 bit2 bit1 bit0 valid overrange code_mon) adc_code_capture_register

tran tran stop=130n maxstep=0.2n errpreset=conservative
save clk load over_lo over_hi din3 din2 din1 din0 bit3 bit2 bit1 bit0 valid overrange code_mon
