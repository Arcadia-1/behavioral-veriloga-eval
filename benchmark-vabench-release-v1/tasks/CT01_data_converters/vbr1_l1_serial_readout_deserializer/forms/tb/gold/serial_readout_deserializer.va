`include "constants.vams"
`include "disciplines.vams"
module serial_readout_deserializer(vdd, vss, clk, frame, serial_in, bit3, bit2, bit1, bit0, word_valid, word_mon);
    inout vdd, vss;
    input clk, frame, serial_in;
    output bit3, bit2, bit1, bit0, word_valid, word_mon;
    electrical vdd, vss, clk, frame, serial_in;
    electrical bit3, bit2, bit1, bit0, word_valid, word_mon;
    parameter real vth = 0.45;
    parameter real tr = 200p;
    integer count;
    integer word;
    integer valid_state;
    real vh;
    analog begin
        vh = V(vdd) - V(vss);
        @(initial_step) begin
            count = 0;
            word = 0;
            valid_state = 0;
        end
        @(cross(V(clk) - vth, +1)) begin
            valid_state = 0;
            if (V(frame) > vth) begin
                word = (V(serial_in) > vth) ? 8 : 0;
                count = 1;
            end else if (count == 1) begin
                if (V(serial_in) > vth) word = word + 4;
                count = 2;
            end else if (count == 2) begin
                if (V(serial_in) > vth) word = word + 2;
                count = 3;
            end else if (count == 3) begin
                if (V(serial_in) > vth) word = word + 1;
                count = 0;
                valid_state = 1;
            end
        end
        V(bit0) <+ V(vss) + transition((word - 2 * (word / 2)) ? vh : 0.0, 0, tr, tr);
        V(bit1) <+ V(vss) + transition(((word / 2) - 2 * (word / 4)) ? vh : 0.0, 0, tr, tr);
        V(bit2) <+ V(vss) + transition(((word / 4) - 2 * (word / 8)) ? vh : 0.0, 0, tr, tr);
        V(bit3) <+ V(vss) + transition((word >= 8) ? vh : 0.0, 0, tr, tr);
        V(word_valid) <+ V(vss) + transition(valid_state ? vh : 0.0, 0, tr, tr);
        V(word_mon) <+ V(vss) + transition(vh * word / 15.0, 0, tr, tr);
    end
endmodule
