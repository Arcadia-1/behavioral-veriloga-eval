`include "constants.vams"
`include "disciplines.vams"
module barrel_pointer_window(clk,rst_n,win0,win1,win2,win3);
    input clk,rst_n; output win0,win1,win2,win3; electrical clk,rst_n,win0,win1,win2,win3; parameter real vth=0.45; parameter real vdd=0.9; parameter real tr=300p; integer idx;
    analog begin @(initial_step) idx=0; @(cross(V(rst_n)-vth,-1)) idx=0; @(cross(V(clk)-vth,+1)) begin if (V(rst_n)>vth) begin idx=idx+1; if (idx>3) idx=0; end end V(win0)<+transition((idx==0 || idx==3)?vdd:0.0,0,tr,tr); V(win1)<+transition((idx==0 || idx==1)?vdd:0.0,0,tr,tr); V(win2)<+transition((idx==1 || idx==2)?vdd:0.0,0,tr,tr); V(win3)<+transition((idx==2 || idx==3)?vdd:0.0,0,tr,tr); end
endmodule
