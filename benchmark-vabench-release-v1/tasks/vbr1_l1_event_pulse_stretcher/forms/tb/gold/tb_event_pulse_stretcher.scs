simulator lang=spectre
global 0

ahdl_include "event_pulse_stretcher.va"

Vtrig (trig 0) vsource type=pwl wave=[0 0 1n 0 1.1n 0.9 1.3n 0 3n 0 3.1n 0.9 3.3n 0 16n 0 16.1n 0.9 16.3n 0 18n 0 18.1n 0.9 18.3n 0 24n 0 24.1n 0.9 24.3n 0 50n 0]
Vrst  (rst  0) vsource type=pwl wave=[0 0 25n 0 25.1n 0.9 28n 0.9 28.1n 0]

XDUT (trig rst pulse) event_pulse_stretcher

tran tran stop=80n maxstep=0.5n
save trig rst pulse
