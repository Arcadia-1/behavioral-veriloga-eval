`include "constants.vams"
`include "disciplines.vams"

module event_pulse_stretcher(trig, rst, pulse);
input trig, rst;
output pulse;
electrical trig, rst, pulse;
parameter real tr = 50p;
parameter real width = 4n;
real level, remaining;
analog begin
    @(initial_step) begin
        level = 0.0;
        remaining = 0.0;
    end
    @(cross(V(trig) - 0.45, +1)) begin
        level = 0.9;
        remaining = width;
    end
    @(timer(0, 0.5n)) begin
        if (V(rst) > 0.45) begin
            level = 0.0;
            remaining = 0.0;
        end else if (remaining > 0.0) begin
            remaining = remaining - 0.5n;
            if (remaining <= 0.0) level = 0.0;
        end
    end
    V(pulse) <+ transition(level, 0, tr, tr);
end
endmodule
