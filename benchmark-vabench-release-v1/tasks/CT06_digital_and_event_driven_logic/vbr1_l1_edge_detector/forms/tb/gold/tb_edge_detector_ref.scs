simulator lang=spectre
global 0

ahdl_include "edge_detector.va"

Vsig (sig 0) vsource type=pulse val0=0 val1=0.9 delay=30n rise=200p fall=200p width=12n period=45n
Vrst (rst_n 0) vsource type=pwl wave=[0 0 10n 0 11n 0.9 180n 0.9]

XDUT (sig rst_n pulse) edge_detector

tran tran stop=180n maxstep=500p
save sig rst_n pulse
