simulator lang=spectre
global 0

ahdl_include "one_shot_timer.va"

Vrst (rst_n 0) vsource type=pulse val0=0 val1=0.9 delay=15n rise=200p fall=200p width=500n period=600n
Vtrig (trig 0) vsource type=pulse val0=0 val1=0.9 delay=40n rise=200p fall=200p width=5n period=45n

XDUT (trig rst_n pulse) one_shot_timer

tran tran stop=260n maxstep=500p
save trig rst_n pulse
